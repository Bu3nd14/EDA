.title KiCad schematic
V1 VIN GND PULSE( 0 1 0 1n 1n 10m 20m )
R1 VIN OUT 1k
C1 OUT GND 100n
.tran 100n 2m
.control
run
wrdata rc_tran_out.txt v(vin) v(out)
quit
.endc
.end
