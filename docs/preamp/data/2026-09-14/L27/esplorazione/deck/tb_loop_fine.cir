tb_loop_fine.cir - SCRATCH (L27): fine cable grid around the jack minimum, block B at 0 and +3 dB, 2.5 k source
* Same circuit as spice/preamp/tb/tb_loop.cir (pos 1, RLOAD 100k and 10k), cable
* 1.8 - 4.2 nF in 0.1 nF steps, to prove the versioned 11-point grid does not
* hide a lower minimum between its points (NEXT-SESSION, L12 buffer lesson).

.include @REPO@/spice/preamp/placeholder_devices.lib
.include @REPO@/models/bjt_pnp/ls350.lib
.include @REPO@/spice/preamp/gain_block_flat.inc

VPP VPLUS 0 DC 15
VMM VMINUS 0 DC -15
VIN VSRCN 0 DC 0
RSRCB VSRCN IN 2.5k

CSTRAY   RG   0 15p
RRG      RG   0 1G
CSTRAY10 RG10 0 15p
RRG10    RG10 0 1G

RBRK FB NBRK 100
VINJ NBRK G2 DC 0 AC 1

RISO   OUT OUTA 47
COUT   OUTA JACK 4.7u
RBLEED JACK 0 220k
RLOAD  JACK 0 100k
CCABLE JACK 0 1f

.control
alter r109 = 1G
set units = degrees
echo "mode,rload,cprobe,fcross_hz,pm_deg" > fine_margini.csv
foreach mode 0 3
  if $mode = 0
    set gm = "0db"
    alter rrg = 1G
    alter rrg10 = 1G
  end
  if $mode = 3
    set gm = "3db"
    alter rrg = 0.1
    alter rrg10 = 1G
  end
  foreach rl 100k 10k
    alter rload = $rl
    foreach cab 1.8n 1.9n 2.0n 2.1n 2.2n 2.3n 2.4n 2.5n 2.6n 2.7n 2.8n 2.9n 3.0n 3.1n 3.2n 3.3n 3.4n 3.5n 3.6n 3.7n 3.8n 3.9n 4.0n 4.1n 4.2n
      alter ccable = $cab
      ac dec 100 1 100meg
      let T = v(fb)/v(g2)
      let Tdb = db(T)
      let Tph = ph(T)
      meas ac fcross when Tdb=0
      meas ac pmarg find Tph when Tdb=0
      echo "$gm,$rl,$cab,$&fcross,$&pmarg" >> fine_margini.csv
      destroy all
    end
  end
end
.endc

.end
