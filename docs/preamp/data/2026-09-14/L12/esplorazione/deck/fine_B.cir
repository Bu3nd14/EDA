fine_B.cir - L12 scratch: block B, fine grid on the remedy candidates, cable at the JACK
* Scratch, not versioned. Candidates k (C124 / C137 / RISO):
*   1 470p/22p/47 (today)  2 1n/22p/47  3 1n/47p/47
*   4 820p/47p/68          5 680p/47p/68  6 820p/22p/68
* Attenuator source 1 mohm .. 2.5 k, load 100 k (cj) and 10 k (future power amp),
* cable 1f, 470p, then 1 n .. 4.7 n in 8 steps. Also |T| at 20 kHz.
* Node names: VSRCN, OUTA, JACK, NBRK - none used by gain_block_flat.inc (#24).

.include @REPO@/spice/preamp/placeholder_devices.lib
.include @REPO@/models/bjt_pnp/ls350.lib
.include @REPO@/spice/preamp/gain_block_flat.inc

VPP VPLUS 0 DC 15
VMM VMINUS 0 DC -15
VIN VSRCN 0 DC 0
RSRCB VSRCN IN 1m

CSTRAY RG 0 15p
RRG    RG 0 1G

RBRK FB NBRK 100
VINJ NBRK G2 DC 0 AC 1

RISO   OUT OUTA 47
COUT   OUTA JACK 4.7u
RBLEED JACK 0 220k
RLOAD  JACK 0 100k
CCABLE JACK 0 1f

.control
alter r109 = 1G
set units = degrees
echo "k,mode,rsrc,rload,ccable,fcross_hz,pm_deg,tdb_10hz,tdb_20k" > fine_B_tab.csv
foreach k 1 2 3 4 5 6
  if $k = 1
    alter c124 = 470p
    alter c137 = 22p
    alter riso = 47
  end
  if $k = 2
    alter c124 = 1n
    alter c137 = 22p
    alter riso = 47
  end
  if $k = 3
    alter c124 = 1n
    alter c137 = 47p
    alter riso = 47
  end
  if $k = 4
    alter c124 = 820p
    alter c137 = 47p
    alter riso = 68
  end
  if $k = 5
    alter c124 = 680p
    alter c137 = 47p
    alter riso = 68
  end
  if $k = 6
    alter c124 = 820p
    alter c137 = 22p
    alter riso = 68
  end
  foreach mode 1G 0.1
    alter rrg = $mode
    foreach rs 1m 500 1k 1.5k 2k 2.5k
      alter rsrcb = $rs
      foreach rl 100k 10k
        alter rload = $rl
        foreach cab 1f 470p 1n 1.5n 1.8n 2.2n 2.7n 3.3n 3.9n 4.7n
          alter ccable = $cab
          ac dec 100 1 100meg
          let T = v(fb)/v(g2)
          let Tdb = db(T)
          let Tph = ph(T)
          meas ac fcross when Tdb=0
          meas ac pmarg find Tph when Tdb=0
          meas ac tdc find Tdb at=10
          meas ac t20k find Tdb at=20000
          echo "$k,$mode,$rs,$rl,$cab,$&fcross,$&pmarg,$&tdc,$&t20k" >> fine_B_tab.csv
          destroy all
        end
      end
    end
  end
end
.endc

.end
