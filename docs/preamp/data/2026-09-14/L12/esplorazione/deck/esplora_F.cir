esplora_F.cir - L12 scratch: fixed-output buffer loop margin, cable at the JACK, remedy candidates
* Scratch, not versioned. Derived from spice/preamp/tb/tb_loop_bufferfissa.cir.
* Sweeps: C124 x C137 x RSEP x headphone amp load x cable at the jack.
* Node names: VSRCN, FIX, JACK, NBRK - none used by gain_block_flat.inc (#24).

.include @REPO@/spice/preamp/placeholder_devices.lib
.include @REPO@/models/bjt_pnp/ls350.lib
.include @REPO@/spice/preamp/gain_block_flat.inc

VPP VPLUS 0 DC 15
VMM VMINUS 0 DC -15
VIN VSRCN 0 DC 0
RSRC VSRCN IN 1

RRG RG 0 1G

RBRK FB NBRK 100
VINJ NBRK G2 DC 0 AC 1

RSEP OUT FIX 47
CFIX FIX JACK 4.7u
RBL  JACK 0 470k
RLD  JACK 0 10k
CPJ  JACK 0 1f

.control
alter r109 = 1G
set units = degrees
echo "c124,c137,rsep,rld,ccable,fcross_hz,pm_deg,tdb_10hz" > esplora_F_tab.csv
foreach cm 470p 560p 680p 820p 1n
  alter c124 = $cm
  foreach cf 22p 47p
    alter c137 = $cf
    foreach ri 47 68
      alter rsep = $ri
      foreach rl 10k 50k
        alter rld = $rl
        foreach cab 1f 100p 470p 1n 1.5n 2.2n 3.3n 4.7n
          alter cpj = $cab
          ac dec 100 1 100meg
          let T = v(fb)/v(g2)
          let Tdb = db(T)
          let Tph = ph(T)
          meas ac fcross when Tdb=0
          meas ac pmarg find Tph when Tdb=0
          meas ac tdc find Tdb at=10
          echo "$cm,$cf,$ri,$rl,$cab,$&fcross,$&pmarg,$&tdc" >> esplora_F_tab.csv
          destroy all
        end
      end
    end
  end
end
.endc

.end
