tb_v2_mute_graduale.cir - V2 al jack (ADR-032): il rilascio lento e il mute graduale, con un elemento ideale, sulla catena intera (L29a, NC-028)
* Prima riga = titolo (docs/limitations.md #10).
*
* COSA MISURA. Che profilo deve avere un mute graduale per rispettare A, B e C
* al jack. L'elemento e' IDEALE: la conduttanza del canale con NMHx = 0, cioe'
* G = 10^(-12 + 13 s) con s che rampa linearmente in T secondi, quindi G
* log-lineare fra 1e-12 S e 10 S (100 mohm a fine corsa, come il contatto).
* Nessuna tecnica e' scelta: il deck consegna un requisito di profilo, non un
* rimedio. Con G log-lineare l'ampiezza al jack cambia quasi tutta mentre G
* attraversa i ~3 decenni attorno a 1/47 S: la dissolvenza EFFICACE e' circa
* 3/13 di T, e va detto accanto a ogni cifra.
* L'analisi e' scripts/v2_metodo.py analizza; la colonna t_grad del manifesto
* estende la finestra di C e l'inizio di B2 a tutta la rampa.
*
* LE POSIZIONI (indice g nei nomi dei file):
*   g1  graduale al jack (JK), in derivazione dopo il condensatore
*   g2  graduale fra i 47 ohm e il 4,7 uF (PRE), in derivazione prima
*   g3  graduale fra i 47 ohm e il 4,7 uF, con l'offset in continua annullato
*       come v3 di tb_v2_mute_varianti.cir (tre giri di .op, tabella
*       tb_v2_mute_graduale_offset.csv): "contatto prima + offset abbassato +
*       rilascio lento"
*   g4  graduale in serie (SER): aperto a mute inserito, ponte RBYx aperto,
*       bleeder lato condensatore 220 k / 470 k
*
* LE CELLE (per posizione e per carico, 100 k e 10 k su tutte e tre le uscite),
* +10 dB, manopola al massimo, T = 20 ms, 200 ms, 1 s, 3 s:
*   _bmT       CON MUSICA, 2,7 V RMS a 1 kHz, fase pi/2: la rampa d'inserzione
*              parte a 1,0 s; quella di rilascio a 1,0 + T + 0,1 s; la corsa
*              finisce 2 s dopo la fine del rilascio
*   _lzT       SENZA SEGNALE: inserzione a 1,0 s, rilascio a 3,0 + T s, 2 s dopo
*   _bmmai, _bmsempre, _lzmai, _lzsempre   riferimenti, uno per posizione e
*              carico, lunghi quanto la cella piu' lunga
*   _b20       solo 100 k e T = 1 s: la stessa cella con musica a 20 Hz, dove il
*              condensatore si carica di piu' (fase pi/2: 1,0 s e 2,1 s sono
*              periodi interi), coi suoi due riferimenti _b20mai, _b20sempre
*
* PROVVISORIO SUI MODELLI: tutto tranne LS352 e' segnaposto, LSK489 compreso
* (LSK489X in placeholder_devices.lib, KF=0; NC-017, NC-031). L'offset
* sistematico e la distorsione, quindi il pavimento di C, dipendono da loro.
*
* CONVENZIONE DI PERCORSO: `.include /Users/roberto/EDA/.claude/worktrees/L29b/...` (tb_op.cir, L2-L3) e file
* scritti con nome nudo nella directory d'uscita di run_simulation.sh.

.include /Users/roberto/EDA/.claude/worktrees/L29b/spice/preamp/placeholder_devices.lib
.include /Users/roberto/EDA/.claude/worktrees/L29b/models/bjt_pnp/ls350.lib
.include /Users/roberto/EDA/.claude/worktrees/L29b/spice/preamp/gain_block.subckt

* >>> CANALE - identico nei tre deck tb_v2_mute_*.cir (v2_metodo.py canale)
* TOLLERANZE (L29a, ripresa 2026-09-16): vedi il blocco esteso in
* tb_v2_mute_varianti.cir. vntol=1e-9 rendeva il deck non eseguibile (41 ore
* per una cella senza segnale); vntol=1e-6 la fa in 5,5 s e le cifre non
* cambiano - verificato, data/2026-09-16/L29a/tolleranze/.
.options reltol=1e-6 vntol=1e-6 abstol=1e-12
VPP VPLUS 0 DC 15
VMM VMINUS 0 DC -15

* ---- sorgente con inviluppo d'entrata ----
VAMP NAMP 0 DC 3.818
VFRQ NFRQ 0 DC 1000
VPHS NPHS 0 DC 0
VTEN NTEN 0 DC 0.3
BSRC SRC 0 V = V(NAMP) * sin(6.283185307179586*V(NFRQ)*time + V(NPHS))
+ * (0.5 - 0.5*cos(3.141592653589793*min(time/V(NTEN), 1)))
VACS SRC SRCX DC 0 AC 1
RSRC SRCX SELA 1.5

* ---- stati dei contatti: t_ins, t_rel, durata graduale, netto(1)/graduale(0) ----
VTIJK NTIJK 0 DC 1000
VTRJK NTRJK 0 DC 2000
VTGJK NTGJK 0 DC 1
VMHJK NMHJK 0 DC 1
BSJKR SJKR 0 V = V(NMHJK)
+ * pwl(time - V(NTIJK), -1e4,0, 0,0, 1u,1, 150u,1, 151u,0, 300u,0, 301u,1, 450u,1, 451u,0, 520u,0, 521u,1, 1e4,1)
+ * pwl(time - V(NTRJK), -1e4,1, 0,1, 1u,0, 400u,0, 401u,1, 600u,1, 601u,0, 1e4,0)
+ + (1 - V(NMHJK)) * min(max((time - V(NTIJK))/V(NTGJK), 0), 1)
+ * (1 - min(max((time - V(NTRJK))/V(NTGJK), 0), 1))
RSJK SJKR SJK 1k
CSJK SJK 0 4.55n
VTIPRE NTIPRE 0 DC 1000
VTRPRE NTRPRE 0 DC 2000
VTGPRE NTGPRE 0 DC 1
VMHPRE NMHPRE 0 DC 1
BSPRER SPRER 0 V = V(NMHPRE)
+ * pwl(time - V(NTIPRE), -1e4,0, 0,0, 1u,1, 150u,1, 151u,0, 300u,0, 301u,1, 450u,1, 451u,0, 520u,0, 521u,1, 1e4,1)
+ * pwl(time - V(NTRPRE), -1e4,1, 0,1, 1u,0, 400u,0, 401u,1, 600u,1, 601u,0, 1e4,0)
+ + (1 - V(NMHPRE)) * min(max((time - V(NTIPRE))/V(NTGPRE), 0), 1)
+ * (1 - min(max((time - V(NTRPRE))/V(NTGPRE), 0), 1))
RSPRE SPRER SPRE 1k
CSPRE SPRE 0 4.55n
VTISER NTISER 0 DC 1000
VTRSER NTRSER 0 DC 2000
VTGSER NTGSER 0 DC 1
VMHSER NMHSER 0 DC 1
BSSERR SSERR 0 V = V(NMHSER)
+ * pwl(time - V(NTISER), -1e4,0, 0,0, 1u,1, 150u,1, 151u,0, 300u,0, 301u,1, 450u,1, 451u,0, 520u,0, 521u,1, 1e4,1)
+ * pwl(time - V(NTRSER), -1e4,1, 0,1, 1u,0, 400u,0, 401u,1, 600u,1, 601u,0, 1e4,0)
+ + (1 - V(NMHSER)) * min(max((time - V(NTISER))/V(NTGSER), 0), 1)
+ * (1 - min(max((time - V(NTRSER))/V(NTGSER), 0), 1))
RSSER SSERR SSER 1k
CSSER SSER 0 4.55n
VTISEL NTISEL 0 DC 1000
VTRSEL NTRSEL 0 DC 2000
VTGSEL NTGSEL 0 DC 1
VMHSEL NMHSEL 0 DC 1
BSSELR SSELR 0 V = V(NMHSEL)
+ * pwl(time - V(NTISEL), -1e4,0, 0,0, 1u,1, 150u,1, 151u,0, 300u,0, 301u,1, 450u,1, 451u,0, 520u,0, 521u,1, 1e4,1)
+ * pwl(time - V(NTRSEL), -1e4,1, 0,1, 1u,0, 400u,0, 401u,1, 600u,1, 601u,0, 1e4,0)
+ + (1 - V(NMHSEL)) * min(max((time - V(NTISEL))/V(NTGSEL), 0), 1)
+ * (1 - min(max((time - V(NTRSEL))/V(NTGSEL), 0), 1))
RSSEL SSELR SSEL 1k
CSSEL SSEL 0 4.55n

* ---- selettore d'ingresso: serie, s = 1 vuol dire APERTO ----
BSEL SELA INA I = V(SELA,INA) * pow(10, -12 + 13*(1 - V(SSEL)))

* ---------------- BLOCCO A: guadagno 1, R_g non montata ------------------
VOSA INA INAX DC 0
XA INAX OUTA FBA RGA RG10A VPLUS VMINUS GAINBLOCK
RRGA RGA 0 1G
CRGA RGA 0 15p
RRG10A RG10A 0 1G
CRG10A RG10A 0 15p

* Attenuatore da 10 k: RATTT a 1 mohm = manopola al massimo.
RATTT OUTA W 1m
RATTB W 0 10k

* ---------------- BUFFER DELLE FISSE (ADR-023): guadagno 1 ---------------
VOSF1 OUTA F1IN DC 0
XF1 F1IN OUTF1 FBF1 RGF1 RG10F1 VPLUS VMINUS GAINBLOCK
RRGF1 RGF1 0 1G
CRGF1 RGF1 0 15p
RRG10F1 RG10F1 0 1G
CRG10F1 RG10F1 0 15p
VOSF2 OUTA F2IN DC 0
XF2 F2IN OUTF2 FBF2 RGF2 RG10F2 VPLUS VMINUS GAINBLOCK
RRGF2 RGF2 0 1G
CRGF2 RGF2 0 15p
RRG10F2 RG10F2 0 1G
CRG10F2 RG10F2 0 15p

RSEP1 OUTF1 FIX1 47
BPRE1 FIX1 0 I = V(FIX1) * pow(10, -12 + 13*V(SPRE))
CFIX1 FIX1 FIXC1 4.7u
RBC1 FIXC1 0 1e12
RBY1 FIXC1 FIXJACK1 1m
BSER1 FIXC1 FIXJACK1 I = V(FIXC1,FIXJACK1) * pow(10, -12 + 13*(1 - V(SSER)))
BJK1 FIXJACK1 0 I = V(FIXJACK1) * pow(10, -12 + 13*V(SJK))
RBL1 FIXJACK1 0 470k
RLD1 FIXJACK1 0 100k

RSEP2 OUTF2 FIX2 47
BPRE2 FIX2 0 I = V(FIX2) * pow(10, -12 + 13*V(SPRE))
CFIX2 FIX2 FIXC2 4.7u
RBC2 FIXC2 0 1e12
RBY2 FIXC2 FIXJACK2 1m
BSER2 FIXC2 FIXJACK2 I = V(FIXC2,FIXJACK2) * pow(10, -12 + 13*(1 - V(SSER)))
BJK2 FIXJACK2 0 I = V(FIXJACK2) * pow(10, -12 + 13*V(SJK))
RBL2 FIXJACK2 0 470k
RLD2 FIXJACK2 0 100k

* ---------------- BLOCCO B: 0 / +3 / +10 dB, due rele' su R_g ------------
* Contatto aperto = 1 G + 15 pF, chiuso = alter ... = 0.1 (ADR-026):
*   0 dB   rrgb = 1G    rrg10b = 1G
*   +3 dB  rrgb = 0.1   rrg10b = 1G
*   +10 dB rrgb = 0.1   rrg10b = 0.1
VOSB W WB DC 0
XB WB OUTB FBB RGB RG10B VPLUS VMINUS GAINBLOCK
RRGB RGB 0 1G
CRGB RGB 0 15p
RRG10B RG10B 0 1G
CRG10B RG10B 0 15p
RISOM OUTB MAIN_A 47
BPREM MAIN_A 0 I = V(MAIN_A) * pow(10, -12 + 13*V(SPRE))
COUTM MAIN_A MAINC 4.7u
RBCM MAINC 0 1e12
RBYM MAINC MAINJACK 1m
BSERM MAINC MAINJACK I = V(MAINC,MAINJACK) * pow(10, -12 + 13*(1 - V(SSER)))
BJKM MAINJACK 0 I = V(MAINJACK) * pow(10, -12 + 13*V(SJK))
RBLM MAINJACK 0 220k
RLDM MAINJACK 0 100k
* <<< CANALE
* capacita' da aperto dell'elemento in serie, e derivazione al jack
CFM MAINC MAINJACK 1f
CF1 FIXC1 FIXJACK1 1f
CF2 FIXC2 FIXJACK2 1f
RSHM MAINJACK 0 1e12
RSH1 FIXJACK1 0 1e12
RSH2 FIXJACK2 0 1e12
.control
alter rrgb = 0.1
alter rrg10b = 0.1
alter vamp dc = 0
alter vmhser dc = 0
alter vtiser dc = -10
alter vtgser dc = 1
alter vtrser dc = 1000
alter rbym = 1e12
alter rby1 = 1e12
alter rby2 = 1e12
alter rbcm = 220k
alter rbc1 = 470k
alter rbc2 = 470k
echo "coff_pF,shunt_ohm,rl,f,main,fix1,main_a,fix1_pre" > coff.csv
alter cfm = 1f
alter cf1 = 1f
alter cf2 = 1f
alter rshm = 1e12
alter rsh1 = 1e12
alter rsh2 = 1e12
alter rldm = 100k
alter rld1 = 100k
alter rld2 = 100k
ac lin 1 20 20
let a = mag(v(mainjack))[0]
let b = mag(v(fixjack1))[0]
let c = mag(v(main_a))[0]
let d = mag(v(fix1))[0]
set va = "$&a"
set vb = "$&b"
set vc = "$&c"
set vd = "$&d"
echo "1f,1e12,100k,20,$va,$vb,$vc,$vd" >> coff.csv
destroy all
ac lin 1 1000 1000
let a = mag(v(mainjack))[0]
let b = mag(v(fixjack1))[0]
let c = mag(v(main_a))[0]
let d = mag(v(fix1))[0]
set va = "$&a"
set vb = "$&b"
set vc = "$&c"
set vd = "$&d"
echo "1f,1e12,100k,1000,$va,$vb,$vc,$vd" >> coff.csv
destroy all
ac lin 1 20000 20000
let a = mag(v(mainjack))[0]
let b = mag(v(fixjack1))[0]
let c = mag(v(main_a))[0]
let d = mag(v(fix1))[0]
set va = "$&a"
set vb = "$&b"
set vc = "$&c"
set vd = "$&d"
echo "1f,1e12,100k,20000,$va,$vb,$vc,$vd" >> coff.csv
destroy all
alter cfm = 1f
alter cf1 = 1f
alter cf2 = 1f
alter rshm = 1e12
alter rsh1 = 1e12
alter rsh2 = 1e12
alter rldm = 10k
alter rld1 = 10k
alter rld2 = 10k
ac lin 1 20 20
let a = mag(v(mainjack))[0]
let b = mag(v(fixjack1))[0]
let c = mag(v(main_a))[0]
let d = mag(v(fix1))[0]
set va = "$&a"
set vb = "$&b"
set vc = "$&c"
set vd = "$&d"
echo "1f,1e12,10k,20,$va,$vb,$vc,$vd" >> coff.csv
destroy all
ac lin 1 1000 1000
let a = mag(v(mainjack))[0]
let b = mag(v(fixjack1))[0]
let c = mag(v(main_a))[0]
let d = mag(v(fix1))[0]
set va = "$&a"
set vb = "$&b"
set vc = "$&c"
set vd = "$&d"
echo "1f,1e12,10k,1000,$va,$vb,$vc,$vd" >> coff.csv
destroy all
ac lin 1 20000 20000
let a = mag(v(mainjack))[0]
let b = mag(v(fixjack1))[0]
let c = mag(v(main_a))[0]
let d = mag(v(fix1))[0]
set va = "$&a"
set vb = "$&b"
set vc = "$&c"
set vd = "$&d"
echo "1f,1e12,10k,20000,$va,$vb,$vc,$vd" >> coff.csv
destroy all
alter cfm = 1f
alter cf1 = 1f
alter cf2 = 1f
alter rshm = 0.1
alter rsh1 = 0.1
alter rsh2 = 0.1
alter rldm = 100k
alter rld1 = 100k
alter rld2 = 100k
ac lin 1 20 20
let a = mag(v(mainjack))[0]
let b = mag(v(fixjack1))[0]
let c = mag(v(main_a))[0]
let d = mag(v(fix1))[0]
set va = "$&a"
set vb = "$&b"
set vc = "$&c"
set vd = "$&d"
echo "1f,0.1,100k,20,$va,$vb,$vc,$vd" >> coff.csv
destroy all
ac lin 1 1000 1000
let a = mag(v(mainjack))[0]
let b = mag(v(fixjack1))[0]
let c = mag(v(main_a))[0]
let d = mag(v(fix1))[0]
set va = "$&a"
set vb = "$&b"
set vc = "$&c"
set vd = "$&d"
echo "1f,0.1,100k,1000,$va,$vb,$vc,$vd" >> coff.csv
destroy all
ac lin 1 20000 20000
let a = mag(v(mainjack))[0]
let b = mag(v(fixjack1))[0]
let c = mag(v(main_a))[0]
let d = mag(v(fix1))[0]
set va = "$&a"
set vb = "$&b"
set vc = "$&c"
set vd = "$&d"
echo "1f,0.1,100k,20000,$va,$vb,$vc,$vd" >> coff.csv
destroy all
alter cfm = 1f
alter cf1 = 1f
alter cf2 = 1f
alter rshm = 0.1
alter rsh1 = 0.1
alter rsh2 = 0.1
alter rldm = 10k
alter rld1 = 10k
alter rld2 = 10k
ac lin 1 20 20
let a = mag(v(mainjack))[0]
let b = mag(v(fixjack1))[0]
let c = mag(v(main_a))[0]
let d = mag(v(fix1))[0]
set va = "$&a"
set vb = "$&b"
set vc = "$&c"
set vd = "$&d"
echo "1f,0.1,10k,20,$va,$vb,$vc,$vd" >> coff.csv
destroy all
ac lin 1 1000 1000
let a = mag(v(mainjack))[0]
let b = mag(v(fixjack1))[0]
let c = mag(v(main_a))[0]
let d = mag(v(fix1))[0]
set va = "$&a"
set vb = "$&b"
set vc = "$&c"
set vd = "$&d"
echo "1f,0.1,10k,1000,$va,$vb,$vc,$vd" >> coff.csv
destroy all
ac lin 1 20000 20000
let a = mag(v(mainjack))[0]
let b = mag(v(fixjack1))[0]
let c = mag(v(main_a))[0]
let d = mag(v(fix1))[0]
set va = "$&a"
set vb = "$&b"
set vc = "$&c"
set vd = "$&d"
echo "1f,0.1,10k,20000,$va,$vb,$vc,$vd" >> coff.csv
destroy all
alter cfm = 0.5p
alter cf1 = 0.5p
alter cf2 = 0.5p
alter rshm = 1e12
alter rsh1 = 1e12
alter rsh2 = 1e12
alter rldm = 100k
alter rld1 = 100k
alter rld2 = 100k
ac lin 1 20 20
let a = mag(v(mainjack))[0]
let b = mag(v(fixjack1))[0]
let c = mag(v(main_a))[0]
let d = mag(v(fix1))[0]
set va = "$&a"
set vb = "$&b"
set vc = "$&c"
set vd = "$&d"
echo "0.5p,1e12,100k,20,$va,$vb,$vc,$vd" >> coff.csv
destroy all
ac lin 1 1000 1000
let a = mag(v(mainjack))[0]
let b = mag(v(fixjack1))[0]
let c = mag(v(main_a))[0]
let d = mag(v(fix1))[0]
set va = "$&a"
set vb = "$&b"
set vc = "$&c"
set vd = "$&d"
echo "0.5p,1e12,100k,1000,$va,$vb,$vc,$vd" >> coff.csv
destroy all
ac lin 1 20000 20000
let a = mag(v(mainjack))[0]
let b = mag(v(fixjack1))[0]
let c = mag(v(main_a))[0]
let d = mag(v(fix1))[0]
set va = "$&a"
set vb = "$&b"
set vc = "$&c"
set vd = "$&d"
echo "0.5p,1e12,100k,20000,$va,$vb,$vc,$vd" >> coff.csv
destroy all
alter cfm = 0.5p
alter cf1 = 0.5p
alter cf2 = 0.5p
alter rshm = 1e12
alter rsh1 = 1e12
alter rsh2 = 1e12
alter rldm = 10k
alter rld1 = 10k
alter rld2 = 10k
ac lin 1 20 20
let a = mag(v(mainjack))[0]
let b = mag(v(fixjack1))[0]
let c = mag(v(main_a))[0]
let d = mag(v(fix1))[0]
set va = "$&a"
set vb = "$&b"
set vc = "$&c"
set vd = "$&d"
echo "0.5p,1e12,10k,20,$va,$vb,$vc,$vd" >> coff.csv
destroy all
ac lin 1 1000 1000
let a = mag(v(mainjack))[0]
let b = mag(v(fixjack1))[0]
let c = mag(v(main_a))[0]
let d = mag(v(fix1))[0]
set va = "$&a"
set vb = "$&b"
set vc = "$&c"
set vd = "$&d"
echo "0.5p,1e12,10k,1000,$va,$vb,$vc,$vd" >> coff.csv
destroy all
ac lin 1 20000 20000
let a = mag(v(mainjack))[0]
let b = mag(v(fixjack1))[0]
let c = mag(v(main_a))[0]
let d = mag(v(fix1))[0]
set va = "$&a"
set vb = "$&b"
set vc = "$&c"
set vd = "$&d"
echo "0.5p,1e12,10k,20000,$va,$vb,$vc,$vd" >> coff.csv
destroy all
alter cfm = 0.5p
alter cf1 = 0.5p
alter cf2 = 0.5p
alter rshm = 0.1
alter rsh1 = 0.1
alter rsh2 = 0.1
alter rldm = 100k
alter rld1 = 100k
alter rld2 = 100k
ac lin 1 20 20
let a = mag(v(mainjack))[0]
let b = mag(v(fixjack1))[0]
let c = mag(v(main_a))[0]
let d = mag(v(fix1))[0]
set va = "$&a"
set vb = "$&b"
set vc = "$&c"
set vd = "$&d"
echo "0.5p,0.1,100k,20,$va,$vb,$vc,$vd" >> coff.csv
destroy all
ac lin 1 1000 1000
let a = mag(v(mainjack))[0]
let b = mag(v(fixjack1))[0]
let c = mag(v(main_a))[0]
let d = mag(v(fix1))[0]
set va = "$&a"
set vb = "$&b"
set vc = "$&c"
set vd = "$&d"
echo "0.5p,0.1,100k,1000,$va,$vb,$vc,$vd" >> coff.csv
destroy all
ac lin 1 20000 20000
let a = mag(v(mainjack))[0]
let b = mag(v(fixjack1))[0]
let c = mag(v(main_a))[0]
let d = mag(v(fix1))[0]
set va = "$&a"
set vb = "$&b"
set vc = "$&c"
set vd = "$&d"
echo "0.5p,0.1,100k,20000,$va,$vb,$vc,$vd" >> coff.csv
destroy all
alter cfm = 0.5p
alter cf1 = 0.5p
alter cf2 = 0.5p
alter rshm = 0.1
alter rsh1 = 0.1
alter rsh2 = 0.1
alter rldm = 10k
alter rld1 = 10k
alter rld2 = 10k
ac lin 1 20 20
let a = mag(v(mainjack))[0]
let b = mag(v(fixjack1))[0]
let c = mag(v(main_a))[0]
let d = mag(v(fix1))[0]
set va = "$&a"
set vb = "$&b"
set vc = "$&c"
set vd = "$&d"
echo "0.5p,0.1,10k,20,$va,$vb,$vc,$vd" >> coff.csv
destroy all
ac lin 1 1000 1000
let a = mag(v(mainjack))[0]
let b = mag(v(fixjack1))[0]
let c = mag(v(main_a))[0]
let d = mag(v(fix1))[0]
set va = "$&a"
set vb = "$&b"
set vc = "$&c"
set vd = "$&d"
echo "0.5p,0.1,10k,1000,$va,$vb,$vc,$vd" >> coff.csv
destroy all
ac lin 1 20000 20000
let a = mag(v(mainjack))[0]
let b = mag(v(fixjack1))[0]
let c = mag(v(main_a))[0]
let d = mag(v(fix1))[0]
set va = "$&a"
set vb = "$&b"
set vc = "$&c"
set vd = "$&d"
echo "0.5p,0.1,10k,20000,$va,$vb,$vc,$vd" >> coff.csv
destroy all
alter cfm = 2p
alter cf1 = 2p
alter cf2 = 2p
alter rshm = 1e12
alter rsh1 = 1e12
alter rsh2 = 1e12
alter rldm = 100k
alter rld1 = 100k
alter rld2 = 100k
ac lin 1 20 20
let a = mag(v(mainjack))[0]
let b = mag(v(fixjack1))[0]
let c = mag(v(main_a))[0]
let d = mag(v(fix1))[0]
set va = "$&a"
set vb = "$&b"
set vc = "$&c"
set vd = "$&d"
echo "2p,1e12,100k,20,$va,$vb,$vc,$vd" >> coff.csv
destroy all
ac lin 1 1000 1000
let a = mag(v(mainjack))[0]
let b = mag(v(fixjack1))[0]
let c = mag(v(main_a))[0]
let d = mag(v(fix1))[0]
set va = "$&a"
set vb = "$&b"
set vc = "$&c"
set vd = "$&d"
echo "2p,1e12,100k,1000,$va,$vb,$vc,$vd" >> coff.csv
destroy all
ac lin 1 20000 20000
let a = mag(v(mainjack))[0]
let b = mag(v(fixjack1))[0]
let c = mag(v(main_a))[0]
let d = mag(v(fix1))[0]
set va = "$&a"
set vb = "$&b"
set vc = "$&c"
set vd = "$&d"
echo "2p,1e12,100k,20000,$va,$vb,$vc,$vd" >> coff.csv
destroy all
alter cfm = 2p
alter cf1 = 2p
alter cf2 = 2p
alter rshm = 1e12
alter rsh1 = 1e12
alter rsh2 = 1e12
alter rldm = 10k
alter rld1 = 10k
alter rld2 = 10k
ac lin 1 20 20
let a = mag(v(mainjack))[0]
let b = mag(v(fixjack1))[0]
let c = mag(v(main_a))[0]
let d = mag(v(fix1))[0]
set va = "$&a"
set vb = "$&b"
set vc = "$&c"
set vd = "$&d"
echo "2p,1e12,10k,20,$va,$vb,$vc,$vd" >> coff.csv
destroy all
ac lin 1 1000 1000
let a = mag(v(mainjack))[0]
let b = mag(v(fixjack1))[0]
let c = mag(v(main_a))[0]
let d = mag(v(fix1))[0]
set va = "$&a"
set vb = "$&b"
set vc = "$&c"
set vd = "$&d"
echo "2p,1e12,10k,1000,$va,$vb,$vc,$vd" >> coff.csv
destroy all
ac lin 1 20000 20000
let a = mag(v(mainjack))[0]
let b = mag(v(fixjack1))[0]
let c = mag(v(main_a))[0]
let d = mag(v(fix1))[0]
set va = "$&a"
set vb = "$&b"
set vc = "$&c"
set vd = "$&d"
echo "2p,1e12,10k,20000,$va,$vb,$vc,$vd" >> coff.csv
destroy all
alter cfm = 2p
alter cf1 = 2p
alter cf2 = 2p
alter rshm = 0.1
alter rsh1 = 0.1
alter rsh2 = 0.1
alter rldm = 100k
alter rld1 = 100k
alter rld2 = 100k
ac lin 1 20 20
let a = mag(v(mainjack))[0]
let b = mag(v(fixjack1))[0]
let c = mag(v(main_a))[0]
let d = mag(v(fix1))[0]
set va = "$&a"
set vb = "$&b"
set vc = "$&c"
set vd = "$&d"
echo "2p,0.1,100k,20,$va,$vb,$vc,$vd" >> coff.csv
destroy all
ac lin 1 1000 1000
let a = mag(v(mainjack))[0]
let b = mag(v(fixjack1))[0]
let c = mag(v(main_a))[0]
let d = mag(v(fix1))[0]
set va = "$&a"
set vb = "$&b"
set vc = "$&c"
set vd = "$&d"
echo "2p,0.1,100k,1000,$va,$vb,$vc,$vd" >> coff.csv
destroy all
ac lin 1 20000 20000
let a = mag(v(mainjack))[0]
let b = mag(v(fixjack1))[0]
let c = mag(v(main_a))[0]
let d = mag(v(fix1))[0]
set va = "$&a"
set vb = "$&b"
set vc = "$&c"
set vd = "$&d"
echo "2p,0.1,100k,20000,$va,$vb,$vc,$vd" >> coff.csv
destroy all
alter cfm = 2p
alter cf1 = 2p
alter cf2 = 2p
alter rshm = 0.1
alter rsh1 = 0.1
alter rsh2 = 0.1
alter rldm = 10k
alter rld1 = 10k
alter rld2 = 10k
ac lin 1 20 20
let a = mag(v(mainjack))[0]
let b = mag(v(fixjack1))[0]
let c = mag(v(main_a))[0]
let d = mag(v(fix1))[0]
set va = "$&a"
set vb = "$&b"
set vc = "$&c"
set vd = "$&d"
echo "2p,0.1,10k,20,$va,$vb,$vc,$vd" >> coff.csv
destroy all
ac lin 1 1000 1000
let a = mag(v(mainjack))[0]
let b = mag(v(fixjack1))[0]
let c = mag(v(main_a))[0]
let d = mag(v(fix1))[0]
set va = "$&a"
set vb = "$&b"
set vc = "$&c"
set vd = "$&d"
echo "2p,0.1,10k,1000,$va,$vb,$vc,$vd" >> coff.csv
destroy all
ac lin 1 20000 20000
let a = mag(v(mainjack))[0]
let b = mag(v(fixjack1))[0]
let c = mag(v(main_a))[0]
let d = mag(v(fix1))[0]
set va = "$&a"
set vb = "$&b"
set vc = "$&c"
set vd = "$&d"
echo "2p,0.1,10k,20000,$va,$vb,$vc,$vd" >> coff.csv
destroy all
alter cfm = 10p
alter cf1 = 10p
alter cf2 = 10p
alter rshm = 1e12
alter rsh1 = 1e12
alter rsh2 = 1e12
alter rldm = 100k
alter rld1 = 100k
alter rld2 = 100k
ac lin 1 20 20
let a = mag(v(mainjack))[0]
let b = mag(v(fixjack1))[0]
let c = mag(v(main_a))[0]
let d = mag(v(fix1))[0]
set va = "$&a"
set vb = "$&b"
set vc = "$&c"
set vd = "$&d"
echo "10p,1e12,100k,20,$va,$vb,$vc,$vd" >> coff.csv
destroy all
ac lin 1 1000 1000
let a = mag(v(mainjack))[0]
let b = mag(v(fixjack1))[0]
let c = mag(v(main_a))[0]
let d = mag(v(fix1))[0]
set va = "$&a"
set vb = "$&b"
set vc = "$&c"
set vd = "$&d"
echo "10p,1e12,100k,1000,$va,$vb,$vc,$vd" >> coff.csv
destroy all
ac lin 1 20000 20000
let a = mag(v(mainjack))[0]
let b = mag(v(fixjack1))[0]
let c = mag(v(main_a))[0]
let d = mag(v(fix1))[0]
set va = "$&a"
set vb = "$&b"
set vc = "$&c"
set vd = "$&d"
echo "10p,1e12,100k,20000,$va,$vb,$vc,$vd" >> coff.csv
destroy all
alter cfm = 10p
alter cf1 = 10p
alter cf2 = 10p
alter rshm = 1e12
alter rsh1 = 1e12
alter rsh2 = 1e12
alter rldm = 10k
alter rld1 = 10k
alter rld2 = 10k
ac lin 1 20 20
let a = mag(v(mainjack))[0]
let b = mag(v(fixjack1))[0]
let c = mag(v(main_a))[0]
let d = mag(v(fix1))[0]
set va = "$&a"
set vb = "$&b"
set vc = "$&c"
set vd = "$&d"
echo "10p,1e12,10k,20,$va,$vb,$vc,$vd" >> coff.csv
destroy all
ac lin 1 1000 1000
let a = mag(v(mainjack))[0]
let b = mag(v(fixjack1))[0]
let c = mag(v(main_a))[0]
let d = mag(v(fix1))[0]
set va = "$&a"
set vb = "$&b"
set vc = "$&c"
set vd = "$&d"
echo "10p,1e12,10k,1000,$va,$vb,$vc,$vd" >> coff.csv
destroy all
ac lin 1 20000 20000
let a = mag(v(mainjack))[0]
let b = mag(v(fixjack1))[0]
let c = mag(v(main_a))[0]
let d = mag(v(fix1))[0]
set va = "$&a"
set vb = "$&b"
set vc = "$&c"
set vd = "$&d"
echo "10p,1e12,10k,20000,$va,$vb,$vc,$vd" >> coff.csv
destroy all
alter cfm = 10p
alter cf1 = 10p
alter cf2 = 10p
alter rshm = 0.1
alter rsh1 = 0.1
alter rsh2 = 0.1
alter rldm = 100k
alter rld1 = 100k
alter rld2 = 100k
ac lin 1 20 20
let a = mag(v(mainjack))[0]
let b = mag(v(fixjack1))[0]
let c = mag(v(main_a))[0]
let d = mag(v(fix1))[0]
set va = "$&a"
set vb = "$&b"
set vc = "$&c"
set vd = "$&d"
echo "10p,0.1,100k,20,$va,$vb,$vc,$vd" >> coff.csv
destroy all
ac lin 1 1000 1000
let a = mag(v(mainjack))[0]
let b = mag(v(fixjack1))[0]
let c = mag(v(main_a))[0]
let d = mag(v(fix1))[0]
set va = "$&a"
set vb = "$&b"
set vc = "$&c"
set vd = "$&d"
echo "10p,0.1,100k,1000,$va,$vb,$vc,$vd" >> coff.csv
destroy all
ac lin 1 20000 20000
let a = mag(v(mainjack))[0]
let b = mag(v(fixjack1))[0]
let c = mag(v(main_a))[0]
let d = mag(v(fix1))[0]
set va = "$&a"
set vb = "$&b"
set vc = "$&c"
set vd = "$&d"
echo "10p,0.1,100k,20000,$va,$vb,$vc,$vd" >> coff.csv
destroy all
alter cfm = 10p
alter cf1 = 10p
alter cf2 = 10p
alter rshm = 0.1
alter rsh1 = 0.1
alter rsh2 = 0.1
alter rldm = 10k
alter rld1 = 10k
alter rld2 = 10k
ac lin 1 20 20
let a = mag(v(mainjack))[0]
let b = mag(v(fixjack1))[0]
let c = mag(v(main_a))[0]
let d = mag(v(fix1))[0]
set va = "$&a"
set vb = "$&b"
set vc = "$&c"
set vd = "$&d"
echo "10p,0.1,10k,20,$va,$vb,$vc,$vd" >> coff.csv
destroy all
ac lin 1 1000 1000
let a = mag(v(mainjack))[0]
let b = mag(v(fixjack1))[0]
let c = mag(v(main_a))[0]
let d = mag(v(fix1))[0]
set va = "$&a"
set vb = "$&b"
set vc = "$&c"
set vd = "$&d"
echo "10p,0.1,10k,1000,$va,$vb,$vc,$vd" >> coff.csv
destroy all
ac lin 1 20000 20000
let a = mag(v(mainjack))[0]
let b = mag(v(fixjack1))[0]
let c = mag(v(main_a))[0]
let d = mag(v(fix1))[0]
set va = "$&a"
set vb = "$&b"
set vc = "$&c"
set vd = "$&d"
echo "10p,0.1,10k,20000,$va,$vb,$vc,$vd" >> coff.csv
destroy all
.endc
.end
