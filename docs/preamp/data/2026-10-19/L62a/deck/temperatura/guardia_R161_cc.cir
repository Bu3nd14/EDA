L62a temperatura guardia_R161_cc
.include @REPO@/models/jfet/lsk489.lib
.include @REPO@/models/bjt_npn/mmbt5551.lib
.include @REPO@/models/bjt_pnp/mmbt5401.lib
.include @REPO@/models/bjt_npn/mje15032.lib
.include @REPO@/models/bjt_pnp/mje15033.lib
.include @REPO@/models/diodes/1n4148.lib
.include @REPO@/models/bjt_pnp/ls350.lib
* GENERATED by circuits/preamp/gain_block.py - DO NOT HAND-EDIT.
* Ports: IN OUT FB RG RG10 VPLUS VMINUS   (node 0 = signal ground)
* RG, RG10: the two gain-relay contact nodes (ADR-026). An open
* contact is a stray capacitance to 0, a closed one a short:
*   0 dB   RG open,   RG10 open
*   +3 dB  RG to 0,   RG10 open
*   +10 dB RG to 0,   RG10 to 0
* Leaving either port unterminated is NOT an open contact.
* Device models: manufacturer models from models/ (L39, NC-017) -
* LSK489A lsk489.lib, MMBT5551 mmbt5551.lib, MMBT5401 mmbt5401.lib,
* LS350 ls350.lib, Qmje15032 mje15032.lib, Qmje15033 mje15033.lib,
* D1N914 1n4148.lib. Include them; none is included here.
.subckt GB IN OUT FB RG RG10 VPLUS VMINUS
C104 NREF VMINUS 100u
C105 NREF VMINUS 100n
C116 NCASC 0 47u
C124 NX NHI 470p
C137 OUT FB 330p
C139 VPLUS 0 100n
C140 VMINUS 0 100n
C141 VPLUS 0 100u
C142 VMINUS 0 100u
C145 VPF 0 1000u
D102 NREF NREFM D1N914
D103 NREFM VMINUS D1N914
JQ110A D1N G1 S1 LSK489A
JQ110B D2N G2 S2 LSK489A
Q106 SRC NREF NTE MMBT5551
Q117 NHI NCASC D1N MMBT5551
Q118 NMIRC NCASC D2N MMBT5551
Q121A NMIRC NMIRI NME1 LS350
Q121B NHI NMIRI NME2 LS350
Q122 NX NVB NVE MMBT5401
Q125 NY NREF NVLE MMBT5551
Q127 NX NBB NY MMBT5551
Q132 VPLUS NBN NEN Qmje15032
Q133 VMINUS NBP NEP Qmje15033
Q146 NFC NHI NVB MMBT5401
Q148 VMINUS NMIRC NMIRI MMBT5401
R101 0 NREF 6.81k
R107 NTE VMINUS 137
R108 IN G1 100
R109 FB G2 100
R111 S1 SRC 100
R112 S2 SRC 200
R113 IN 0 1MEG
R114 VPLUS NCASC 4.99k
R115 NCASC 0 10.0k
R119 VPF NME1 220
R120 VPF NME2 220
R123 VPF NVE 56
R126 NVLE VMINUS 56
R128 NX NBB 1.58k
R129 NBB NY 1.00k
R130 NX NBN 10
R131 NY NBP 10
R134 NEN OUT 22
R135 NEP OUT 22
R136 OUT FB 1.50k
R138 FB RG 3.57k
R143 FB RG10 866
R144 VPLUS VPF 20
R147 VPF NVB 1.2k
R149 VPF NMIRI 10k
R150 FB G2 4.7k
R151 S2 SRC 200
R152 VPLUS VPF 20
R153 NFC VMINUS 4.7k
* L62a, variante guardia (NC-062): parti aggiunte
Q160 NX NBG NY MMBT5551
R161 NX NBG 1m
R162 NBG NY 1k
.ends GB
VPP VPLUS 0 DC 15
VMM VMINUS 0 DC -15
XB 0 OUT FB RG RG10 VPLUS VMINUS GB
CS RG 0 15p
RL RG 0 1G
CS2 RG10 0 15p
RL2 RG10 0 1G
RISO OUT OUTA 47
COUT OUTA JACK 4.7u
RB JACK 0 220k
RLD JACK 0 100k
.control
option itl1=1000
option temp=27
op
echo "L62A_T 27"
print i(vpp) @q.xb.q132[ic] @q.xb.q133[ic] v(xb.nx)-v(xb.ny) @q.xb.q127[ic] v(out)
option temp=60
op
echo "L62A_T 60"
print i(vpp) @q.xb.q132[ic] @q.xb.q133[ic] v(xb.nx)-v(xb.ny) @q.xb.q127[ic] v(out)
option temp=90
op
echo "L62A_T 90"
print i(vpp) @q.xb.q132[ic] @q.xb.q133[ic] v(xb.nx)-v(xb.ny) @q.xb.q127[ic] v(out)
quit
.endc
.end
