L62b sorg L45a tr A g0 Q132_be musica=0 mute=0 - guasto a 0.3 s
.include @REPO@/models/jfet/lsk489.lib
.include @REPO@/models/bjt_npn/mmbt5551.lib
.include @REPO@/models/bjt_pnp/mmbt5401.lib
.include @REPO@/models/bjt_npn/mje15032.lib
.include @REPO@/models/bjt_pnp/mje15033.lib
.include @REPO@/models/diodes/1n4148.lib
.include @REPO@/models/bjt_pnp/ls350.lib
.include @REPO@/docs/preamp/data/2026-11-02/L66/varianti/sorg/gain_block.subckt
.include @REPO@/docs/preamp/data/2026-11-02/L66/inc/sorg/Q132_be.subckt
* interruttori: SWFC corto del guasto (chiuso con CTL=1), SWFO aperto del guasto (chiuso con
* CTL=0); SWKO / SWKC i due contatti del deviatore del mute (0,1 ohm, ADR-044): MUTE=0 rilasciato
.model SWFC SW(VT=0.5 VH=0.1 RON=0.01 ROFF=1e12)
.model SWFO SW(VT=-0.5 VH=0.1 RON=0.01 ROFF=1e12)
.model SWKO SW(VT=-0.5 VH=0.1 RON=0.1 ROFF=1e12)
.model SWKC SW(VT=0.5 VH=0.1 RON=0.1 ROFF=1e12)
VPP VPLUS 0 DC 15
VMM VMINUS 0 DC -15
VCTL CTL 0 PWL(0 0 0.3 0 0.30001 1)
VMUTE MUTE 0 DC 0
VIN SRC 0 DC 0
RSRC SRC JIN 1.5
CIN JIN SEL 1u
RJ JIN 0 10MEG
RSEL SEL 0 470k
RSELK SEL INA 0.1
XA INA OUTA FBA RGA RG10A VPLUS VMINUS CTL GAINBLOCKG
RRGA RGA 0 1G
CRGA RGA 0 15p
RRG10A RG10A 0 1G
CRG10A RG10A 0 15p
XF1 OUTA OUTF1 FBF1 RGF1 RG10F1 VPLUS VMINUS GAINBLOCK
RRGF1 RGF1 0 1G
CRGF1 RGF1 0 15p
RRG10F1 RG10F1 0 1G
CRG10F1 RG10F1 0 15p
XF2 OUTA OUTF2 FBF2 RGF2 RG10F2 VPLUS VMINUS GAINBLOCK
RRGF2 RGF2 0 1G
CRGF2 RGF2 0 15p
RRG10F2 RG10F2 0 1G
CRG10F2 RG10F2 0 15p
* scala del trim (845 + 464 + 464, sempre montata), trim a 0 dB, C_T, volume al massimo
RTR1 OUTA TAP6 845
RTR2 TAP6 TAP12 464
RTR3 TAP12 0 464
CT OUTA ATT 10u
RVT ATT W 1m
RVB W 0 10k
XB W OUTB FBB RGB RG10B VPLUS VMINUS GAINBLOCK
RRGB RGB 0 1G
CRGB RGB 0 15p
RRG10B RG10B 0 1G
CRG10B RG10B 0 15p
RSMAIN OUTB MAIN_A 47
CMAIN MAIN_A MAINC 4.7u
RBCMAIN MAINC 0 220k
SNOMAIN MAINC MAINJACK 0 MUTE SWKO
SNCMAIN MAINC 0 MUTE 0 SWKC
RBLMAIN MAINJACK 0 220k
RLDMAIN MAINJACK 0 100k
RSFIX1 OUTF1 FIX1_A 47
CFIX1 FIX1_A FIX1C 4.7u
RBCFIX1 FIX1C 0 470k
SNOFIX1 FIX1C FIX1JACK 0 MUTE SWKO
SNCFIX1 FIX1C 0 MUTE 0 SWKC
RBLFIX1 FIX1JACK 0 470k
RLDFIX1 FIX1JACK 0 10k
RSFIX2 OUTF2 FIX2_A 47
CFIX2 FIX2_A FIX2C 4.7u
RBCFIX2 FIX2C 0 470k
SNOFIX2 FIX2C FIX2JACK 0 MUTE SWKO
SNCFIX2 FIX2C 0 MUTE 0 SWKC
RBLFIX2 FIX2JACK 0 470k
RLDFIX2 FIX2JACK 0 50k
.control
set noaskquit
option itl1=1000
save v(vplus) v(vminus) v(xa.vpf) v(xa.nx) v(xa.nhi) v(xa.nvb) v(xa.nve) v(xa.nvs) v(xa.ny) v(xa.nbb) v(xa.nbn) v(xa.nen) v(xa.nbp) v(xa.nep) v(xa.nvle) v(xa.nref) v(outa) v(xa.nme1) v(xa.nme2) v(xa.nmirc) v(xa.nmiri) v(xa.d1n) v(xa.d2n) v(xa.src) @q.xa.q122[ic] @q.xa.q193[ic] @q.xa.q125[ic] @q.xa.q127[ic] @q.xa.q132[ic] @q.xa.q133[ic] @q.xa.q146[ic] @q.xa.q121a[ic] @q.xa.q121b[ic] @q.xa.q148[ic] @q.xa.q106[ic] @q.xa.q122[ib] @q.xa.q193[ib] @q.xa.q125[ib] @q.xa.q127[ib] @q.xa.q132[ib] @q.xa.q133[ib] @q.xa.q146[ib] @q.xa.q121a[ib] @q.xa.q121b[ib] @q.xa.q148[ib] @q.xa.q106[ib] @q.xa.q122[p] @q.xa.q193[p] @q.xa.q125[p] @q.xa.q127[p] @q.xa.q132[p] @q.xa.q133[p] @q.xa.q146[p] @q.xa.q121a[p] @q.xa.q121b[p] @q.xa.q148[p] @q.xa.q106[p]
tran 1u 2.3 0 50u
meas tran v_vplus AVG v(vplus) from=2.29 to=2.3
meas tran v_vminus AVG v(vminus) from=2.29 to=2.3
meas tran v_vpf AVG v(xa.vpf) from=2.29 to=2.3
meas tran v_nx AVG v(xa.nx) from=2.29 to=2.3
meas tran v_nhi AVG v(xa.nhi) from=2.29 to=2.3
meas tran v_nvb AVG v(xa.nvb) from=2.29 to=2.3
meas tran v_nve AVG v(xa.nve) from=2.29 to=2.3
meas tran v_nvs AVG v(xa.nvs) from=2.29 to=2.3
meas tran v_ny AVG v(xa.ny) from=2.29 to=2.3
meas tran v_nbb AVG v(xa.nbb) from=2.29 to=2.3
meas tran v_nbn AVG v(xa.nbn) from=2.29 to=2.3
meas tran v_nen AVG v(xa.nen) from=2.29 to=2.3
meas tran v_nbp AVG v(xa.nbp) from=2.29 to=2.3
meas tran v_nep AVG v(xa.nep) from=2.29 to=2.3
meas tran v_nvle AVG v(xa.nvle) from=2.29 to=2.3
meas tran v_nref AVG v(xa.nref) from=2.29 to=2.3
meas tran v_outa AVG v(outa) from=2.29 to=2.3
meas tran v_nme1 AVG v(xa.nme1) from=2.29 to=2.3
meas tran v_nme2 AVG v(xa.nme2) from=2.29 to=2.3
meas tran v_nmirc AVG v(xa.nmirc) from=2.29 to=2.3
meas tran v_nmiri AVG v(xa.nmiri) from=2.29 to=2.3
meas tran v_d1n AVG v(xa.d1n) from=2.29 to=2.3
meas tran v_d2n AVG v(xa.d2n) from=2.29 to=2.3
meas tran v_src AVG v(xa.src) from=2.29 to=2.3
meas tran ic_q122 AVG @q.xa.q122[ic] from=2.29 to=2.3
meas tran ib_q122 AVG @q.xa.q122[ib] from=2.29 to=2.3
meas tran p_q122 AVG @q.xa.q122[p] from=2.29 to=2.3
meas tran ic_q193 AVG @q.xa.q193[ic] from=2.29 to=2.3
meas tran ib_q193 AVG @q.xa.q193[ib] from=2.29 to=2.3
meas tran p_q193 AVG @q.xa.q193[p] from=2.29 to=2.3
meas tran ic_q125 AVG @q.xa.q125[ic] from=2.29 to=2.3
meas tran ib_q125 AVG @q.xa.q125[ib] from=2.29 to=2.3
meas tran p_q125 AVG @q.xa.q125[p] from=2.29 to=2.3
meas tran ic_q127 AVG @q.xa.q127[ic] from=2.29 to=2.3
meas tran ib_q127 AVG @q.xa.q127[ib] from=2.29 to=2.3
meas tran p_q127 AVG @q.xa.q127[p] from=2.29 to=2.3
meas tran ic_q132 AVG @q.xa.q132[ic] from=2.29 to=2.3
meas tran ib_q132 AVG @q.xa.q132[ib] from=2.29 to=2.3
meas tran p_q132 AVG @q.xa.q132[p] from=2.29 to=2.3
meas tran ic_q133 AVG @q.xa.q133[ic] from=2.29 to=2.3
meas tran ib_q133 AVG @q.xa.q133[ib] from=2.29 to=2.3
meas tran p_q133 AVG @q.xa.q133[p] from=2.29 to=2.3
meas tran ic_q146 AVG @q.xa.q146[ic] from=2.29 to=2.3
meas tran ib_q146 AVG @q.xa.q146[ib] from=2.29 to=2.3
meas tran p_q146 AVG @q.xa.q146[p] from=2.29 to=2.3
meas tran ic_q121a AVG @q.xa.q121a[ic] from=2.29 to=2.3
meas tran ib_q121a AVG @q.xa.q121a[ib] from=2.29 to=2.3
meas tran p_q121a AVG @q.xa.q121a[p] from=2.29 to=2.3
meas tran ic_q121b AVG @q.xa.q121b[ic] from=2.29 to=2.3
meas tran ib_q121b AVG @q.xa.q121b[ib] from=2.29 to=2.3
meas tran p_q121b AVG @q.xa.q121b[p] from=2.29 to=2.3
meas tran ic_q148 AVG @q.xa.q148[ic] from=2.29 to=2.3
meas tran ib_q148 AVG @q.xa.q148[ib] from=2.29 to=2.3
meas tran p_q148 AVG @q.xa.q148[p] from=2.29 to=2.3
meas tran ic_q106 AVG @q.xa.q106[ic] from=2.29 to=2.3
meas tran ib_q106 AVG @q.xa.q106[ib] from=2.29 to=2.3
meas tran p_q106 AVG @q.xa.q106[p] from=2.29 to=2.3
.endc
.end
