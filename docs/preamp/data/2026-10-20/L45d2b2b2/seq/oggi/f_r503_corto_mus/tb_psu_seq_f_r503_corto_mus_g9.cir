* L47c2a tb_psu seq f_r503_corto_mus (giro 9) - GENERATED by genera_tb_psu.py from /Users/roberto/EDA/.claude/worktrees/L45d2b2b2/circuits/preamp/psu.net and /Users/roberto/EDA/.claude/worktrees/L45d2b2b2/docs/preamp/data/2026-10-20/L45d2b2b2/seq/oggi/f_r503_corto_mus/core_g8.csv

.include /Users/roberto/EDA/.claude/worktrees/L45d2b2b2/models/diodes/1n4148.lib
.include /Users/roberto/EDA/.claude/worktrees/L45d2b2b2/models/mosfet_n/generic_nmos.lib
.include /Users/roberto/EDA/.claude/worktrees/L45d2b2b2/models/mosfet_p/generic_pmos.lib
.include /Users/roberto/EDA/.claude/worktrees/L45d2b2b2/models/bjt_npn/generic_npn.lib
.include /Users/roberto/EDA/.claude/worktrees/L45d2b2b2/models/bjt_pnp/generic_pnp.lib
* declared generic models (L41a): bridge diode, Schottky, 24 V zener; L41b1: BAT54
.model DBR D(Is=1e-9 N=1.8 Rs=0.03)
.model DSCH D(Is=1e-6 N=1.1 Rs=0.05)
.model DZ24 D(Is=1e-12 N=1 Rs=1 BV=24 IBV=1m)
.model DBAT54 D(Is=2e-8 N=1.05 Rs=1)

* behavioural positive / negative regulator: gm to VSET, clamped to [0, ILIM],
* dropout VDO, no reverse current, input current = output current + IQ
.subckt REGP in out gnd en VSET=15 VDO=0.3 ILIM=1 IQ=1m
Bo gnd out I = V(en)*min({ILIM}, max(0, 1000*(min({VSET}, V(in,gnd)-{VDO}) - V(out,gnd))))
Bi in gnd I = V(en)*min({ILIM}, max(0, 1000*(min({VSET}, V(in,gnd)-{VDO}) - V(out,gnd)))) + {IQ}*(V(in,gnd)>1)
Rl out gnd 1meg
.ends
.subckt REGM in out gnd en VSET=15 VDO=0.3 ILIM=1 IQ=1m
Bo out gnd I = V(en)*min({ILIM}, max(0, 1000*(min({VSET}, V(gnd,in)-{VDO}) - V(gnd,out))))
Bi gnd in I = V(en)*min({ILIM}, max(0, 1000*(min({VSET}, V(gnd,in)-{VDO}) - V(gnd,out)))) + {IQ}*(V(gnd,in)>1)
Rl out gnd 1meg
.ends
* L45d2b2a (NC-063): the same two regulators WITH their soft-start. A reference node r (1 F) is
* charged while EN is high and IN is above the UVLO, and discharged in 1 ms otherwise (ASSUMED:
* the datasheets do not say how fast NR is discharged); the output regulates to min(VSET, V(r)).
*  - TPS7A4701 (SBVS204G, UVLO 2.67 V rising): r charges by RC, time constant TAU = 100 kOhm x C_NR,
*    towards VSET + 5 V, so that it reaches VSET at TAU ln((VSET + 5) / 5) - eq. 5, the only figure
*    the datasheet gives (a typical device; the shape before it is ASSUMED);
*  - TPS7A3301 (SBVS169D, UVLO -2 V): r rises linearly to VSET in TSS = 1.2 ms per nF - eq. 1 (the
*    linear ramp is ASSUMED, as fig. 29 draws it).
.subckt REGPSS in out gnd en VSET=15 VDO=0.3 ILIM=1 IQ=1m TAU=1
* (a 0 V sense on IN: i(v.x<ref>.vsns) is the current the regulator draws, positive)
Vsns in ins 0
Bon on 0 V = V(en)*0.5*(1+tanh((V(ins,gnd)-2.67)/0.05))
Cr r 0 1
Br 0 r I = V(on)*({VSET}+5-V(r))/{TAU} - (1-V(on))*V(r)/1m
Bo gnd out I = V(en)*min({ILIM}, max(0, 1000*(min(min({VSET}, V(r)), V(ins,gnd)-{VDO}) - V(out,gnd))))
Bi ins gnd I = V(en)*min({ILIM}, max(0, 1000*(min(min({VSET}, V(r)), V(ins,gnd)-{VDO}) - V(out,gnd)))) + {IQ}*(V(ins,gnd)>1)
Rl out gnd 1meg
.ends
.subckt REGMSS in out gnd en VSET=15 VDO=0.3 ILIM=1 IQ=1m TSS=1
Vsns ins in 0
Bon on 0 V = V(en)*0.5*(1+tanh((V(gnd,ins)-2)/0.05))
Cr r 0 1
Br 0 r I = V(on)*{VSET}/{TSS}*0.5*(1-tanh((V(r)-{VSET}-0.5)/0.05)) - (1-V(on))*V(r)/1m
Bo out gnd I = V(en)*min({ILIM}, max(0, 1000*(min(min({VSET}, V(r)), V(gnd,ins)-{VDO}) - V(gnd,out))))
Bi gnd ins I = V(en)*min({ILIM}, max(0, 1000*(min(min({VSET}, V(r)), V(gnd,ins)-{VDO}) - V(gnd,out)))) + {IQ}*(V(gnd,ins)>1)
Rl out gnd 1meg
.ends
* behavioural open-drain comparator: output sinks when inn > inp, 1 us,
* high impedance with its supply below 2 V; 55 uA from its supply (L41b1)
.subckt CMPOD inp inn out vcc gnd
Bu u gnd V = 0.5*(1+tanh((V(inn)-V(inp))/1m)) * 0.5*(1+tanh((V(vcc,gnd)-2)/0.1))
Ru u uf 1k
Cu uf gnd 1n
Bs out gnd I = V(out,gnd)/50 * V(uf,gnd)
Rleak out gnd 1G
Bq vcc gnd I = 55u*(V(vcc,gnd)>1)
.ends
* behavioural LM4040-2.5 shunt
.subckt SHUNT25 k a
Bz k a I = max(0, V(k,a)-2.5)*20
.ends

.model DSB340 D(Is=8.7e-5 N=1.47 Rs=0.0136)
CC501 raw_p c501_esr {0.8*4700u}
RC501_esr c501_esr 0 0.03
CC502 0 c502_esr {0.8*4700u}
RC502_esr c502_esr raw_m 0.03
CC505 vplus c505_esr {0.8*2200u}
RC505_esr c505_esr 0 0.03
CC506 0 c506_esr {0.8*2200u}
RC506_esr c506_esr vminus 0.03
CC507 nr_p 0 4.7u
CC508 0 nr_m 470n
CC509 raw_pr 0 10u
CC510 0 raw_mr 10u
CC511 vplus_reg 0 10u
CC512 0 vminus_reg 10u
CC513 vminus_reg fb_m 10n
CC514 vref rly_ret 100n
CC515 sup_p rly_ret 1n
CC516 sup_m rly_ret 1n
CC517 v5 rly_ret 100n
CC518 md rly_ret 100n
CC519 v5 rly_ret 100n
CC520 raw_v c520_esr {0.8*4700u}
RC520_esr c520_esr rly_ret 0.03
CC521 nr_v rly_ret 10u
CC522 raw_v rly_ret 10u
CC523 vrelay_reg c523_esr {0.8*2200u}
RC523_esr c523_esr rly_ret 0.03
CC524 vrelay_reg rly_ret 1u
CC525 v5 rly_ret 1u
CC526 sup_vr rly_ret 1n
CC527 mute_g rly_ret 22n
CC528 permit_t rly_ret 100n
CC529 vr_t rly_ret 100n
CC530 v5 rly_ret 100n
CC531 sw_g vrelay_reg 100n
CC532 front_in rly_ret 100n
CC533 mute_sw_in rly_ret 100n
CC534 v5 rly_ret 100n
DD501a t1_sec_a raw_p DBR
DD501b t1_sec_b raw_p DBR
DD501c raw_m t1_sec_a DBR
DD501d raw_m t1_sec_b DBR
DD503a t2_sec_a rect_v DBR
DD503b t2_sec_b rect_v DBR
DD503c rly_ret t2_sec_a DBR
DD503d rly_ret t2_sec_b DBR
DD504 rect_v raw_v DSCH
DD505 mains_coil vrelay_reg D1N914
DD506 mute_cmd clamp_mute D1N914
DD507 si_d507_2 clamp_mute DZ24
DD508 permit_cmd clamp_permit D1N914
DD509 si_d509_2 clamp_permit DZ24
DD510 vplus_reg sd_d510 DSB340
VSDD510 sd_d510 raw_pr 0
DD511 raw_mr sd_d511 DSB340
VSDD511 sd_d511 vminus_reg 0
DD512 vrelay_reg raw_v DSCH
DD513 vplus_reg sd_d513 DSB340
VSDD513 sd_d513 raw_pr 0
DD514 raw_mr sd_d514 DSB340
VSDD514 sd_d514 vminus_reg 0
DD515 vplus_reg sd_d515 DSB340
VSDD515 sd_d515 vplus 0
DD516 vminus sd_d516 DSB340
VSDD516 sd_d516 vminus_reg 0
DD520 pt_a permit_t D1N914
DD521 pt_b permit_t D1N914
DD522 mute_g permit_g DBAT54
DD523 permit_t vr_t D1N914
DD524 ve_a vr_t D1N914
RF501 ac_l t2_pri_l 1m
RK501_coil vrelay_reg mains_coil 360
RNT501 rly_ret 0 1m
MQ501 si_q501_3 mute_g rly_ret rly_ret MNGEN W=2000u L=1u
MQ502 si_q502_3 permit_g rly_ret rly_ret MNGEN W=2000u L=1u
MQ503 si_q503_3 mains_g rly_ret rly_ret MNGEN W=2000u L=1u
QQ504 si_q504_3 si_q504_1 rly_ret QNGEN
MQ505 si_q505_3 sw_g vrelay_reg vrelay_reg MPGEN W=28000u L=1u
MQ506 sw_d vr_g rly_ret rly_ret MNGEN W=2000u L=1u
RR501 vminus_reg fb_m 120k
RR502 fb_m 0 10k
RR503 v5 vref 2k
RR504 vref vref_half 10k
RR505 vref_half rly_ret 10k
RR506 vplus sup_p 44.2k
RR507 sup_p rly_ret 10k
RR508 vref sup_m 10k
RR509 sup_m vminus 118k
RR510 rect_v md_b 22k
RR511 md_b rly_ret 4.7k
RR512 v5 md 220k
RR513 mute_req mute_g 10k
RR514 mute_g rly_ret 100k
RR516 permit_g rly_ret 100k
RR517 v5 mute_sw 100k
RR518 v5 front_sw 100k
RR520 mains_req mains_g 10k
RR521 mains_g rly_ret 100k
RR522 vrelay_reg sup_vr 34k
RR523 sup_vr rly_ret 10k
RR524 v5 permit_g 10k
RR525 mute_req rly_ret 100k
RR526 permit_req rly_ret 100k
RR527 vrelay_en rly_ret 100k
RR528 mains_req rly_ret 100k
RR532 mute_req pt_a 1k
RR533 permit_req pt_b 1k
RR534 permit_t rly_ret 332k
RR535 vrelay_en ve_a 1k
RR536 vr_t rly_ret 1MEG
RR537 v5 vr_g 10k
RR538 vr_g rly_ret 100k
RR539 sw_d sw_g 47k
RR540 sw_g vrelay_reg 100k
RR541 front_sw front_in 1k
RR542 mute_sw mute_sw_in 1k
RR543 mute_g mute_g_in 1MEG
RR544 sup_p adc_sup_p 47k
RR545 sup_m adc_sup_m 47k
RR546 sup_vr adc_sup_vr 47k
RR547 md adc_md 47k
RR550 raw_p raw_pr 4.7
RR551 raw_mr raw_m 4.7
XU501 raw_pr vplus_reg 0 en_u501 REGPSS VSET=15.3 VDO=0.3 ILIM=1 IQ=0.58m TAU=0.47
VENU501 en_u501 0 pwl(0 1 1000 1)
XU502 raw_mr vminus_reg 0 en_u502 REGMSS VSET=15.288 VDO=0.3 ILIM=1 IQ=1m TSS=0.564
VENU502 en_u502 0 pwl(0 1 1000 1)
XU503 raw_v si_u503_1 rly_ret en_u503 REGPSS VSET=12 VDO=0.3 ILIM=1 IQ=0.58m TAU=1
VENU503 en_u503 0 pwl(0 1 1000 1)
XU504 vrelay_reg si_u504_3 rly_ret en_u504 REGP VSET=5 VDO=0.6 ILIM=0.25 IQ=2u
VENU504 en_u504 0 pwl(0 1 1000 1)
XU505a sup_p vref mute_g v5 rly_ret CMPOD
XU505b vref_half sup_m mute_g v5 rly_ret CMPOD
XU506a vref md mute_g v5 rly_ret CMPOD
XU506b sup_vr vref mute_g v5 rly_ret CMPOD
XU507 si_u507_1 rly_ret SHUNT25
XU508a permit_t vref permit_g v5 rly_ret CMPOD
XU508b vr_t vref vr_g v5 rly_ret CMPOD
BU509q v5 rly_ret I = V(iq_mcu)
BU509_10 0 permit_req I = V(drv_permit_req)*(V(set_permit_req)*V(v5,rly_ret) - V(permit_req,rly_ret))/50
BU509_11 0 mute_req I = V(drv_mute_req)*(V(set_mute_req)*V(v5,rly_ret) - V(mute_req,rly_ret))/50
RU509_12 front_in rly_ret 1G
RU509_13 mute_sw_in rly_ret 1G
RU509_14 mute_g_in rly_ret 1G
RU509_16 updi rly_ret 1G
RU509_3 adc_sup_p rly_ret 1G
RU509_4 adc_sup_m rly_ret 1G
RU509_5 adc_sup_vr rly_ret 1G
RU509_6 adc_md rly_ret 1G
BU509_8 0 vrelay_en I = V(drv_vrelay_en)*(V(set_vrelay_en)*V(v5,rly_ret) - V(vrelay_en,rly_ret))/50
BU509_9 0 mains_req I = V(drv_mains_req)*(V(set_mains_req)*V(v5,rly_ret) - V(mains_req,rly_ret))/50
VSID507_2 vrelay si_d507_2 0
VSID509_2 vrelay si_d509_2 0
VSIQ501_3 mute_cmd si_q501_3 0
VSIQ502_3 permit_cmd si_q502_3 0
VSIQ503_3 mains_coil si_q503_3 0
VSIQ504_1 md_b si_q504_1 0
VSIQ504_3 md si_q504_3 0
VSIQ505_3 vrelay si_q505_3 0
VSIU503_1 vrelay_reg si_u503_1 0
VSIU504_3 v5 si_u504_3 0
VSIU507_1 vref si_u507_1 0
* L45d2b2a soft-start: U501 C507 = 4.7e-06 F: tau 0.47 s, t_SS = tau ln((15.3 + 5) / 5) = 0.6586 s (eq. 5)
* L45d2b2a soft-start: U502 C508 = 4.7e-07 F: t_SS = 1.2 ms/nF = 0.564 s (eq. 1)
* L45d2b2a soft-start: U503 C521 = 1e-05 F: tau 1 s, t_SS = tau ln((12 + 5) / 5) = 1.224 s (eq. 5)
R_float_ac_l ac_l 0 1G
R_float_ac_n ac_n 0 1G
R_float_t1_pri_l t1_pri_l 0 1G
R_float_t1_pri_n t1_pri_n 0 1G
R_float_t2_pri_l t2_pri_l 0 1G
VENV env 0 pwl(0 1 1000 1)
BK501 k501_in 0 V = 0.5*(1+tanh((V(vrelay_reg,mains_coil)-8.4)/0.2))
RK501 k501_in k501_f 5k
CK501 k501_f 0 1u
BENV1 env1 0 V = V(env)*0.5*(1+tanh((V(k501_f)-0.5)/0.02))
BT1_SEC_Aa T1_SEC_Aa_e 0 V = V(env1)*22.9103*sin(2*pi*50*time)
VT1a_sns T1_SEC_Aa_e T1_SEC_Aa_i 0
BT1_SEC_Ab 0 T1_SEC_Ab_e V = V(env1)*22.9103*sin(2*pi*50*time)
VT1b_sns T1_SEC_Ab_e T1_SEC_Ab_i 0
RT1_SEC_Aa T1_SEC_Aa_i T1_SEC_Aa_l 0.7200
LT1_SEC_Aa T1_SEC_Aa_l t1_sec_a 100u
RT1_SEC_Ab T1_SEC_Ab_i T1_SEC_Ab_l 0.7200
LT1_SEC_Ab T1_SEC_Ab_l t1_sec_b 100u
BT2_SEC_A T2_SEC_A_e t2_sec_b V = V(env)*20.3647*sin(2*pi*50*time)
VT2_sns T2_SEC_A_e T2_SEC_A_i 0
RT2_SEC_A T2_SEC_A_i T2_SEC_A_l 5.7600
LT2_SEC_A T2_SEC_A_l t2_sec_a 100u
RT2_SEC_A_float t2_sec_b 0 10meg
VSET_mute_req set_mute_req 0 pwl(0 1 2.000204 1 2.000205 0 2.02 0 2.020001 1 2.05 1 2.050001 0 2.07 0 2.070001 1 2.09 1 2.090001 0 2.11 0 2.110001 1 2.13 1 2.130001 0 2.15 0 2.150001 1 2.17 1 2.170001 0 2.19 0 2.190001 1 2.2 1 2.200001 0 2.22 0 2.220001 1 2.23 1 2.230001 0 2.25 0 2.250001 1 2.26 1 2.260001 0 2.28 0 2.280001 1 2.29 1 2.290001 0 2.31 0 2.310001 1 2.32 1 2.320001 0 2.34 0 2.340001 1 2.35 1 2.350001 0 2.37 0 2.370001 1 2.38 1 2.380001 0 2.4 0 2.400001 1 2.41 1 2.410001 0 2.43 0 2.430001 1 2.44 1 2.440001 0 2.46 0 2.460001 1 2.47 1 2.470001 0 2.49 0 2.490001 1 2.5 1 2.500001 0 2.52 0 2.520001 1 2.53 1 2.530001 0 2.55 0 2.550001 1 2.56 1 2.560001 0 2.58 0 2.580001 1 2.59 1 2.590001 0 2.61 0 2.610001 1 2.62 1 2.620001 0 2.64 0 2.640001 1 2.65 1 2.650001 0 2.67 0 2.670001 1 2.68 1 2.680001 0 2.7 0 2.700001 1 2.71 1 2.710001 0 2.73 0 2.730001 1 2.74 1 2.740001 0 2.76 0 2.760001 1 2.77 1 2.770001 0 2.79 0 2.790001 1 2.8 1 2.800001 0 2.82 0 2.820001 1 2.83 1 2.830001 0 2.85 0 2.850001 1 2.86 1 2.860001 0 2.88 0 2.880001 1 2.89 1 2.890001 0 2.91 0 2.910001 1 2.92 1 2.920001 0 2.94 0 2.940001 1 2.95 1 2.950001 0 2.97 0 2.970001 1 2.98 1 2.980001 0 3 0 3.000001 1 1000 1)
VDRV_mute_req drv_mute_req 0 pwl(0 1 1000 1)
VSET_permit_req set_permit_req 0 pwl(0 1 2.000204 1 2.000205 0 2.02 0 2.020001 1 2.05 1 2.050001 0 2.07 0 2.070001 1 2.09 1 2.090001 0 2.11 0 2.110001 1 2.13 1 2.130001 0 2.15 0 2.150001 1 2.17 1 2.170001 0 2.19 0 2.190001 1 2.2 1 2.200001 0 2.22 0 2.220001 1 2.23 1 2.230001 0 2.25 0 2.250001 1 2.26 1 2.260001 0 2.28 0 2.280001 1 2.29 1 2.290001 0 2.31 0 2.310001 1 2.32 1 2.320001 0 2.34 0 2.340001 1 2.35 1 2.350001 0 2.37 0 2.370001 1 2.38 1 2.380001 0 2.4 0 2.400001 1 2.41 1 2.410001 0 2.43 0 2.430001 1 2.44 1 2.440001 0 2.46 0 2.460001 1 2.47 1 2.470001 0 2.49 0 2.490001 1 2.5 1 2.500001 0 2.52 0 2.520001 1 2.53 1 2.530001 0 2.55 0 2.550001 1 2.56 1 2.560001 0 2.58 0 2.580001 1 2.59 1 2.590001 0 2.61 0 2.610001 1 2.62 1 2.620001 0 2.64 0 2.640001 1 2.65 1 2.650001 0 2.67 0 2.670001 1 2.68 1 2.680001 0 2.7 0 2.700001 1 2.71 1 2.710001 0 2.73 0 2.730001 1 2.74 1 2.740001 0 2.76 0 2.760001 1 2.77 1 2.770001 0 2.79 0 2.790001 1 2.8 1 2.800001 0 2.82 0 2.820001 1 2.83 1 2.830001 0 2.85 0 2.850001 1 2.86 1 2.860001 0 2.88 0 2.880001 1 2.89 1 2.890001 0 2.91 0 2.910001 1 2.92 1 2.920001 0 2.94 0 2.940001 1 2.95 1 2.950001 0 2.97 0 2.970001 1 2.98 1 2.980001 0 3 0 3.000001 1 1000 1)
VDRV_permit_req drv_permit_req 0 pwl(0 1 1000 1)
VSET_mains_req set_mains_req 0 pwl(0 1 1000 1)
VDRV_mains_req drv_mains_req 0 pwl(0 1 1000 1)
VSET_vrelay_en set_vrelay_en 0 pwl(0 1 1000 1)
VDRV_vrelay_en drv_vrelay_en 0 pwl(0 1 1000 1)
VIQ iq_mcu 0 pwl(0 0.002 1000 0.002)
VGF_c gf_c 0 pwl(0 0 2 0 2.000001 1 1000 1)
BF_c v5 fc_s I = V(v5,vref)*10*V(gf_c)
VFC fc_s vref 0
RLOADP vplus 0 49.4441
RLOADM 0 vminus 48.1481
CAUDIOP vplus 0 800.8u
RCELLE vplus vpf_celle 1.25
CCELLE vpf_celle 0 8000u
CAUDIOM 0 vminus 800.8u
RMUTECOIL vrelay mute_cmd 401.167
RPERMITCOIL vrelay permit_cmd 1315
RRESTO vrelay rly_ret 233.01
BTRIM vrelay rly_ret I = 0.0364*max(0, V(vrelay,rly_ret))/12*0.5*(1+tanh((V(permit_cmd,rly_ret)-6)/0.5))
VGSW3 g_sw3 0 pwl(0 1 1000 1)
BSW3 mute_sw rly_ret I = V(mute_sw,rly_ret)*V(g_sw3)
VGFRONT g_front 0 pwl(0 1 1000 1)
BFRONT front_sw rly_ret I = V(front_sw,rly_ret)*V(g_front)
.options reltol=1e-4 abstol=1e-10 vntol=1e-6 temp=25 method=gear gmin=1e-10
.control
set numdgt=12
set wr_singlescale
set wr_vecnames
option numdgt=12
tran 100u 3 0 20u uic
linearize
wrdata tb_psu_seq_f_r503_corto_mus_g9_out.txt v(front_in) v(mute_sw_in) v(mute_g_in) v(adc_sup_p) v(adc_sup_m) v(adc_sup_vr) v(adc_md) v(mute_cmd) v(permit_cmd) v(vrelay) v(vrelay_reg) v(vplus) v(vminus) v(k501_f) v(mute_g) v(permit_g) v(env) v(mute_req) v(permit_req) v(mains_req) v(vrelay_en) v(vr_g) v(mains_g) v(raw_p) v(raw_m) i(v.xu501.vsns) i(v.xu502.vsns) v(raw_pr) v(raw_mr) i(vsdd510) i(vsdd511) i(vsdd513) i(vsdd514) i(vsdd515) i(vsdd516) v(vplus_reg) v(vminus_reg) i(vsid507_2) i(vsid509_2) i(vsiq501_3) i(vsiq502_3) i(vsiq503_3) i(vsiq504_1) i(vsiq504_3) i(vsiq505_3) i(vsiu503_1) i(vsiu504_3) i(vsiu507_1) i(vfc) v(rly_ret) v(raw_v) v(v5) v(vref) v(md) v(md_b) v(rect_v) v(clamp_mute) v(clamp_permit) v(mains_coil) v(sw_g)
.endc
.end
