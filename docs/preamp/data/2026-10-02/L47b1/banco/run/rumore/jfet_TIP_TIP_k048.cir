rumore jfet ('TIP', 'TIP', 'k048')
* GENERATO da docs/preamp/data/2026-10-02/L47b1/banco/ (L47b1). Banco ridotto: vedi comune.py.
.include /Users/roberto/EDA/.claude/worktrees/L47b1/docs/preamp/data/2026-10-02/L47b1/banco/inc/jfet_angoli.lib
.include /Users/roberto/EDA/.claude/worktrees/L47b1/models/optocoupler/nsl32sr3_comportamentale.lib
.options reltol=1e-6 vntol=1e-6 abstol=1e-12
VSRC VSN 0 DC 0 AC 1 SIN(0 3.818 1k)
RSRC VSN SRCX 1.5
* R_IN del blocco A (gain_block.py, r_in=1M)
RIN AIN 0 1MEG
* ---- la cella a JFET: serie TIP, derivazione TIP, correttivo k048 ----
JS AIN GS SRCX MMBFJ112_TIP
JP AIN GP 0 MMBFJ112_TIP
RCS GS CSF 470k
RCP GP CPF 470k
RFS CS CSF 100k
CFS CSF 0 100n
RFP CP CPF 100k
CFP CPF 0 100n
VCS CS 0 DC 0
VCP CP 0 DC -15
RS1 GS SRCX 1MEG
RS2 GS AIN 1MEG
RP1 GP AIN 1MEG
RP2 GP 0 1MEG
.control
option itl1=1000
set numdgt=10
noise v(ain) vsrc dec 50 20 20k
setplot noise2
let vn = sqrt(onoise_total^2)
print vn
setplot noise1
destroy all
alter vsrc ac = 0
alter vcs ac = 1
ac dec 50 20 20k
let h2 = mag(v(ain))^2
let hrms_vcs = sqrt(mean(h2))
let hmax_vcs = vecmax(mag(v(ain)))
print hrms_vcs hmax_vcs
destroy all
alter vcs ac = 0
alter vsrc ac = 0
alter vcp ac = 1
ac dec 50 20 20k
let h2 = mag(v(ain))^2
let hrms_vcp = sqrt(mean(h2))
let hmax_vcp = vecmax(mag(v(ain)))
print hrms_vcp hmax_vcp
destroy all
alter vcp ac = 0
.endc
.end
