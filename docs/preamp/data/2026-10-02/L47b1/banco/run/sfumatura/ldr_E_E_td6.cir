sfumatura ldr_E_E_td6
* GENERATO da docs/preamp/data/2026-10-02/L47b1/banco/ (L47b1). Banco ridotto: vedi comune.py.
.include /Users/roberto/EDA/.claude/worktrees/L47b1/docs/preamp/data/2026-10-02/L47b1/banco/inc/jfet_angoli.lib
.include /Users/roberto/EDA/.claude/worktrees/L47b1/models/optocoupler/nsl32sr3_comportamentale.lib
.options reltol=1e-6 vntol=1e-6 abstol=1e-12
VSRC VSN 0 DC 0 AC 1 SIN(0 3.818 1k)
RSRC VSN SRCX 1.5
* R_IN del blocco A (gain_block.py, r_in=1M)
RIN AIN 0 1MEG
* ---- la cella a fotoresistenze NSL-32SR3: serie curva E, derivazione curva E ----
XLS ALS 0 SRCX AIN NSL32SR3_E
XLP ALP 0 AIN 0 NSL32SR3_E
* 10 M dall'anodo a massa: un LED col solo generatore non ha percorso in continua (L29b)
RALS ALS 0 10MEG
RALP ALP 0 10MEG
* il profilo v4 (ADR-040), come genera_tb_v2_casopeggiore.py
BILS 0 ALS I = pow(10, pwl(V(DEP), 0,-1.6990, 0.1,-3.6990, 0.45,-5.3468, 0.75,-6.7212, 0.8,-8.0000, 1,-8.0000))
BILP 0 ALP I = 1e-08 * pow(2e+06, min(max((V(DEP) - 0.5)/0.5, 0), 1))
BDEP DEP 0 V = time < 7.3 ? min(max((time - 0.3)/6, 0), 1) : min(max(1 - (time - 7.3)/6, 0), 1)
.control
option itl1=1000
set numdgt=15
* il pieno di partenza: lo stato in gioco (d = 0) e' l'op
tran 10u 13.8 0 10u
wrdata ldr_E_E_td6.dat v(ain) v(xls.xs) v(xlp.xs)
.endc
.end
