tb_dc_headroom__b_r133.cir - L40 ESPLORAZIONE da tb_dc_headroom.cir, RG0L40 FB 0 7.87k; alter r138 = 6.49k; alter c137 = 220p; alter c124 = 560p; alter r128 = 1.33k
* Answers three separate questions that are easy to confuse:
*   1. where does the OUTPUT stage clip (V+/V- minus the drops)?
*   2. where does the INPUT pair run out of common-mode range (the price
*      ADR-014's cascode charges - see the 8.485 V note in gain_block.py)?
*   3. is the clipping symmetric? (V3 cares: an asymmetric clip pumps DC
*      into the 4.7 uF output cap and the recovery is then seconds long.)
* Vds of both LSK489 halves is written out alongside Vout so that (2) shows
* up as a curve, not as a guess.
* Models are the manufacturer's since L39 (NC-017). Clipping levels depend on
* Vce(sat) and Vbe: simulated on those models, not measured on a prototype.
*
* Path convention: see the comment in tb_op.cir (settled in L2). Reads use
* @REPO@/<path-from-repo-root>; writes use a bare wrdata name.
*
* This deck writes THREE wrdata files (L27: the +3 dB mode of ADR-026), so
* the bare names cannot all be <basename>_wrdata.txt. The mapping is not
* guessable from the names, so it is stated here and on each mode below:
*   tb_dc_headroom_wrdata.txt -> 0 dB mode   (both open: RRG = RRG10 = 1 Gohm)
*   tb_dc_headroom_3db.txt    -> +3 dB mode  (K1 closed: RRG = 0.1, RRG10 = 1G)
*   tb_dc_headroom_10db.txt   -> +10 dB mode (both closed: RRG = RRG10 = 0.1)
* run_simulation.sh converts the first via its primary path (that name is
* what it looks for first) and the second via its second pass, which
* converts every wrdata file the run produced.

.include @REPO@/models/jfet/lsk489.lib
.include @REPO@/models/bjt_npn/mmbt5551.lib
.include @REPO@/models/bjt_pnp/mmbt5401.lib
.include @REPO@/models/bjt_npn/mje15032.lib
.include @REPO@/models/bjt_pnp/mje15033.lib
.include @REPO@/models/diodes/1n4148.lib
* L39 (NC-017): every active device in this deck is a vendor model from
* models/, each next to its .provenance.json:
*   LSK489   - vendor model LSK489A, the published corner sample (I_DSS
*              2.59 mA, below the group-B window of ADR-031)
*   LS352    - vendor model LS350 (ADR-018), included on the next line
*   MMBT5551 - vendor model, Diodes Inc. (ADR-017)
*   MMBT5401 - vendor model, Diodes Inc. (ADR-017)
*   MJE15032 - vendor model Qmje15032, onsemi (NC-024, NC-025)
*   MJE15033 - vendor model Qmje15033, onsemi (NC-025)
*   1N4148   - vendor model D1N914, onsemi (docs/limitations.md #20)
* Only the LSK489A carries KF: 1/f noise is on the input pair and nowhere
* else. No model carries part-to-part spread.
.include @REPO@/models/bjt_pnp/ls350.lib
.include @REPO@/spice/preamp/gain_block_flat.inc

VPP VPLUS 0 DC 15
VMM VMINUS 0 DC -15
VIN IN 0 DC 0

* gain relay contacts (ADR-026), altered inside .control
CSTRAY   RG   0 15p
RRG      RG   0 1G
CSTRAY10 RG10 0 15p
RRG10    RG10 0 1G

RISO  OUT OUTA 47
COUT  OUTA JACK 4.7u
RBLEED JACK 0 220k
RLOAD JACK 0 100k

* L40: righe di netlist in piu' (varianti.py)
RG0L40 FB 0 7.87k
.control
* L40: variante
alter r138 = 6.49k
alter c137 = 220p
alter c124 = 560p
alter r128 = 1.33k
show r138 : resistance
show c137 : capacitance
show c124 : capacitance
show r128 : resistance
show rg0l40 : resistance
* ---------- 0 dB mode: both contacts open ----------
alter rrg = 1G
alter rrg10 = 1G
dc VIN -14 14 0.05
wrdata tb_dc_headroom_wrdata.txt v(OUT) v(D1N)-v(S1) v(D2N)-v(S2) v(NX) v(NY)
* ---------- +3 dB mode: K1 closed, K5 open ----------
alter rrg = 0.1
alter rrg10 = 1G
dc VIN -14 14 0.05
wrdata tb_dc_headroom_3db.txt v(OUT) v(D1N)-v(S1) v(D2N)-v(S2) v(NX) v(NY)
* ---------- +10 dB mode: both contacts closed ----------
alter rrg = 0.1
alter rrg10 = 0.1
dc VIN -14 14 0.05
wrdata tb_dc_headroom_10db.txt v(OUT) v(D1N)-v(S1) v(D2N)-v(S2) v(NX) v(NY)
.endc

.end
