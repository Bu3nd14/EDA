* L41a tb_psu guasti - GENERATED by genera_tb_psu.py from /Users/roberto/EDA/.claude/worktrees/L41a/circuits/preamp/psu.net

.include /Users/roberto/EDA/.claude/worktrees/L41a/models/diodes/1n4148.lib
.include /Users/roberto/EDA/.claude/worktrees/L41a/models/mosfet_n/generic_nmos.lib
.include /Users/roberto/EDA/.claude/worktrees/L41a/models/bjt_npn/generic_npn.lib
* declared generic models (L41a): bridge diode, Schottky, 24 V zener
.model DBR D(Is=1e-9 N=1.8 Rs=0.03)
.model DSCH D(Is=1e-6 N=1.1 Rs=0.05)
.model DZ24 D(Is=1e-12 N=1 Rs=1 BV=24 IBV=1m)

* behavioural positive / negative regulator: gm to VSET, clamped to [0, ILIM],
* dropout VDO, no reverse current, input current = output current + 1 mA
.subckt REGP in out gnd en VSET=15 VDO=0.3 ILIM=1
Bo gnd out I = V(en)*min({ILIM}, max(0, 1000*(min({VSET}, V(in,gnd)-{VDO}) - V(out,gnd))))
Bi in gnd I = V(en)*min({ILIM}, max(0, 1000*(min({VSET}, V(in,gnd)-{VDO}) - V(out,gnd)))) + 1m*(V(in,gnd)>1)
Rl out gnd 1meg
.ends
.subckt REGM in out gnd en VSET=15 VDO=0.3 ILIM=1
Bo out gnd I = V(en)*min({ILIM}, max(0, 1000*(min({VSET}, V(gnd,in)-{VDO}) - V(gnd,out))))
Bi gnd in I = V(en)*min({ILIM}, max(0, 1000*(min({VSET}, V(gnd,in)-{VDO}) - V(gnd,out)))) + 1m*(V(gnd,in)>1)
Rl out gnd 1meg
.ends
* behavioural open-drain comparator: output sinks when inn > inp, 1 us,
* high impedance with its supply below 2 V
.subckt CMPOD inp inn out vcc gnd
Bu u gnd V = 0.5*(1+tanh((V(inn)-V(inp))/1m)) * 0.5*(1+tanh((V(vcc,gnd)-2)/0.1))
Ru u uf 1k
Cu uf gnd 1n
Bs out gnd I = V(out,gnd)/50 * V(uf,gnd)
Rleak out gnd 1G
.ends
* behavioural LM4040-2.5 shunt
.subckt SHUNT25 k a
Bz k a I = max(0, V(k,a)-2.5)*20
.ends

CC501 raw_p c501_esr {0.8*4700u}
RC501_esr c501_esr 0 0.03
CC502 0 c502_esr {0.8*4700u}
RC502_esr c502_esr raw_m 0.03
CC505 vplus c505_esr {0.8*2200u}
RC505_esr c505_esr 0 0.03
CC506 0 c506_esr {0.8*2200u}
RC506_esr c506_esr vminus 0.03
CC507 nr_p 0 10u
CC508 0 nr_m 10u
CC509 raw_p 0 10u
CC510 0 raw_m 10u
CC511 vplus 0 10u
CC512 0 vminus 10u
CC513 vminus fb_m 10n
CC514 vref rly_ret 100n
CC515 sup_p rly_ret 1n
CC516 sup_m rly_ret 1n
CC517 v5 rly_ret 100n
CC518 md rly_ret 100n
CC519 v5 rly_ret 100n
CC520 raw_v c520_esr {0.8*4700u}
RC520_esr c520_esr rly_ret 0.03
CC521 nr_v rly_ret 10u
CC522 raw_v rly_ret 10u
CC523 vrelay c523_esr {0.8*2200u}
RC523_esr c523_esr rly_ret 0.03
CC524 vrelay rly_ret 1u
CC525 v5 rly_ret 1u
CC526 sup_vr rly_ret 1n
DD501a t1_sec_a raw_p DBR
DD501b t1_sec_b raw_p DBR
DD501c raw_m t1_sec_a DBR
DD501d raw_m t1_sec_b DBR
DD503a t2_sec_a rect_v DBR
DD503b t2_sec_b rect_v DBR
DD503c rly_ret t2_sec_a DBR
DD503d rly_ret t2_sec_b DBR
DD504 rect_v raw_v DSCH
DD505 mains_coil vrelay D1N914
DD506 mute_cmd clamp_mute D1N914
DD507 vrelay clamp_mute DZ24
DD508 permit_cmd clamp_permit D1N914
DD509 vrelay clamp_permit DZ24
DD510 vplus raw_p DSCH
DD511 raw_m vminus DSCH
DD512 vrelay raw_v DSCH
RF501 ac_l t2_pri_l 1m
RK501_coil vrelay mains_coil 360
RNT501 rly_ret 0 1m
MQ501 mute_cmd mute_g rly_ret rly_ret MNGEN W=2000u L=1u
MQ502 permit_cmd permit_g rly_ret rly_ret MNGEN W=2000u L=1u
MQ503 mains_coil mains_g rly_ret rly_ret MNGEN W=2000u L=1u
QQ504 md md_b rly_ret QNGEN
RR501 vminus fb_m 118k
RR502 fb_m 0 10k
RR503 v5 vref 2k
RR504 vref vref_half 10k
RR505 vref_half rly_ret 10k
RR506 vplus sup_p 44.2k
RR507 sup_p rly_ret 10k
RR508 vref sup_m 10k
RR509 sup_m vminus 118k
RR510 rect_v md_b 22k
RR511 md_b rly_ret 4.7k
RR512 v5 md 220k
RR513 mute_req mute_g 10k
RR514 mute_g rly_ret 100k
RR515 permit_req permit_g 10k
RR516 permit_g rly_ret 100k
RR517 v5 mute_sw 100k
RR518 v5 front_sw 100k
RR520 mains_req mains_g 10k
RR521 mains_g rly_ret 100k
RR522 vrelay sup_vr 34k
RR523 sup_vr rly_ret 10k
XU501 raw_p vplus 0 en_u501 REGP VSET=15 VDO=0.3 ILIM=1
VENU501 en_u501 0 pwl(0 1 1000 1)
XU502 raw_m vminus 0 en_u502 REGM VSET=15.0528 VDO=0.3 ILIM=1
VENU502 en_u502 0 pwl(0 1 1000 1)
XU503 raw_v vrelay rly_ret en_u503 REGP VSET=12 VDO=0.3 ILIM=1
VENU503 en_u503 0 pwl(0 1 1000 1)
XU504 vrelay v5 rly_ret en_u504 REGP VSET=5 VDO=0.6 ILIM=0.25
VENU504 en_u504 0 pwl(0 1 1000 1)
XU505a sup_p vref mute_g v5 rly_ret CMPOD
XU505b vref_half sup_m mute_g v5 rly_ret CMPOD
XU506a vref md mute_g v5 rly_ret CMPOD
XU506b sup_vr vref mute_g v5 rly_ret CMPOD
XU507 vref rly_ret SHUNT25
R_float_ac_l ac_l 0 1G
R_float_ac_n ac_n 0 1G
R_float_t1_pri_l t1_pri_l 0 1G
R_float_t1_pri_n t1_pri_n 0 1G
R_float_t2_pri_l t2_pri_l 0 1G
VENV env 0 pwl(0 1 1000 1)
BT1_SEC_Aa T1_SEC_Aa_i 0 V = V(env)*22.9103*sin(2*pi*50*time)
BT1_SEC_Ab 0 T1_SEC_Ab_i V = V(env)*22.9103*sin(2*pi*50*time)
RT1_SEC_Aa T1_SEC_Aa_i T1_SEC_Aa_l 0.7200
LT1_SEC_Aa T1_SEC_Aa_l t1_sec_a 100u
RT1_SEC_Ab T1_SEC_Ab_i T1_SEC_Ab_l 0.7200
LT1_SEC_Ab T1_SEC_Ab_l t1_sec_b 100u
BT2_SEC_A T2_SEC_A_i t2_sec_b V = V(env)*20.3647*sin(2*pi*50*time)
RT2_SEC_A T2_SEC_A_i T2_SEC_A_l 5.7600
LT2_SEC_A T2_SEC_A_l t2_sec_a 100u
RT2_SEC_A_float t2_sec_b 0 10meg
IPLUS vplus 0 dc 0 pwl(0 0 0.5 0.265)
IMINUS 0 vminus dc 0 pwl(0 0 0.5 0.265)
RMUTECOIL vrelay mute_cmd 438.333
RPERMITCOIL vrelay permit_cmd 1315
RRESTO vrelay rly_ret 283.019
VMUTEREQ mute_req rly_ret pwl(0 0 1.0 0 1.001 5)
VPERMITREQ permit_req rly_ret pwl(0 0 1.0 0 1.001 5)
VMAINSREQ mains_req rly_ret dc 5
RSW3 mute_sw rly_ret 1
RFRONT front_sw rly_ret 1
.options reltol=1e-4 abstol=1e-10 vntol=1e-6
.control
set numdgt=15
* ---- guasto_u501 ----
alter @venv[pwl] = [ 0 1 1000 1 ]
alter @venu501[pwl] = [ 0 1 1000 1 ]
alter @venu502[pwl] = [ 0 1 1000 1 ]
alter @venu503[pwl] = [ 0 1 1000 1 ]
alter @venu504[pwl] = [ 0 1 1000 1 ]
alter rr512 = 220k
alter @venu501[pwl] = [ 0 1 2 1 2 0 1000 0 ]
print @rr512[resistance]
tran 20u 2.3 0 20u uic
wrdata /Users/roberto/EDA/.claude/worktrees/L41a/docs/preamp/data/2026-09-26/L41a/guasti/guasto_u501.txt v(vplus) v(vminus) v(vrelay) v(v5) v(raw_p) v(raw_m) v(raw_v) v(rect_v) v(mute_g) v(permit_g) v(md) v(sup_p) v(sup_m) v(vref) v(mute_cmd) v(permit_cmd) v(mains_coil)
destroy all
* ---- guasto_u502 ----
alter @venv[pwl] = [ 0 1 1000 1 ]
alter @venu501[pwl] = [ 0 1 1000 1 ]
alter @venu502[pwl] = [ 0 1 1000 1 ]
alter @venu503[pwl] = [ 0 1 1000 1 ]
alter @venu504[pwl] = [ 0 1 1000 1 ]
alter rr512 = 220k
alter @venu502[pwl] = [ 0 1 2 1 2 0 1000 0 ]
print @rr512[resistance]
tran 20u 2.3 0 20u uic
wrdata /Users/roberto/EDA/.claude/worktrees/L41a/docs/preamp/data/2026-09-26/L41a/guasti/guasto_u502.txt v(vplus) v(vminus) v(vrelay) v(v5) v(raw_p) v(raw_m) v(raw_v) v(rect_v) v(mute_g) v(permit_g) v(md) v(sup_p) v(sup_m) v(vref) v(mute_cmd) v(permit_cmd) v(mains_coil)
destroy all
* ---- guasto_u503 ----
alter @venv[pwl] = [ 0 1 1000 1 ]
alter @venu501[pwl] = [ 0 1 1000 1 ]
alter @venu502[pwl] = [ 0 1 1000 1 ]
alter @venu503[pwl] = [ 0 1 1000 1 ]
alter @venu504[pwl] = [ 0 1 1000 1 ]
alter rr512 = 220k
alter @venu503[pwl] = [ 0 1 2 1 2 0 1000 0 ]
print @rr512[resistance]
tran 20u 2.3 0 20u uic
wrdata /Users/roberto/EDA/.claude/worktrees/L41a/docs/preamp/data/2026-09-26/L41a/guasti/guasto_u503.txt v(vplus) v(vminus) v(vrelay) v(v5) v(raw_p) v(raw_m) v(raw_v) v(rect_v) v(mute_g) v(permit_g) v(md) v(sup_p) v(sup_m) v(vref) v(mute_cmd) v(permit_cmd) v(mains_coil)
destroy all
* ---- perdita_senza_rivelatore_m10 ----
alter @venv[pwl] = [ 0 0.9 2 0.9 2.0001 0 1000 0 ]
alter @venu501[pwl] = [ 0 1 1000 1 ]
alter @venu502[pwl] = [ 0 1 1000 1 ]
alter @venu503[pwl] = [ 0 1 1000 1 ]
alter @venu504[pwl] = [ 0 1 1000 1 ]
alter rr512 = 220k
alter rr512 = 1e15
print @rr512[resistance]
tran 20u 2.4 0 20u uic
wrdata /Users/roberto/EDA/.claude/worktrees/L41a/docs/preamp/data/2026-09-26/L41a/guasti/perdita_senza_rivelatore_m10.txt v(vplus) v(vminus) v(vrelay) v(v5) v(raw_p) v(raw_m) v(raw_v) v(rect_v) v(mute_g) v(permit_g) v(md) v(sup_p) v(sup_m) v(vref) v(mute_cmd) v(permit_cmd) v(mains_coil)
destroy all
* ---- perdita_senza_rivelatore_nom ----
alter @venv[pwl] = [ 0 1 2 1 2.0001 0 1000 0 ]
alter @venu501[pwl] = [ 0 1 1000 1 ]
alter @venu502[pwl] = [ 0 1 1000 1 ]
alter @venu503[pwl] = [ 0 1 1000 1 ]
alter @venu504[pwl] = [ 0 1 1000 1 ]
alter rr512 = 220k
alter rr512 = 1e15
print @rr512[resistance]
tran 20u 2.4 0 20u uic
wrdata /Users/roberto/EDA/.claude/worktrees/L41a/docs/preamp/data/2026-09-26/L41a/guasti/perdita_senza_rivelatore_nom.txt v(vplus) v(vminus) v(vrelay) v(v5) v(raw_p) v(raw_m) v(raw_v) v(rect_v) v(mute_g) v(permit_g) v(md) v(sup_p) v(sup_m) v(vref) v(mute_cmd) v(permit_cmd) v(mains_coil)
destroy all
* ---- perdita_senza_rivelatore_p10 ----
alter @venv[pwl] = [ 0 1.1 2 1.1 2.0001 0 1000 0 ]
alter @venu501[pwl] = [ 0 1 1000 1 ]
alter @venu502[pwl] = [ 0 1 1000 1 ]
alter @venu503[pwl] = [ 0 1 1000 1 ]
alter @venu504[pwl] = [ 0 1 1000 1 ]
alter rr512 = 220k
alter rr512 = 1e15
print @rr512[resistance]
tran 20u 2.4 0 20u uic
wrdata /Users/roberto/EDA/.claude/worktrees/L41a/docs/preamp/data/2026-09-26/L41a/guasti/perdita_senza_rivelatore_p10.txt v(vplus) v(vminus) v(vrelay) v(v5) v(raw_p) v(raw_m) v(raw_v) v(rect_v) v(mute_g) v(permit_g) v(md) v(sup_p) v(sup_m) v(vref) v(mute_cmd) v(permit_cmd) v(mains_coil)
destroy all
.endc
.end
