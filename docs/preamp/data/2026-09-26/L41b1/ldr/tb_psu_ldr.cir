* L41b1 tb_psu ldr - GENERATED by genera_tb_psu.py from /Users/roberto/EDA/.claude/worktrees/L41b1-temporizzatore-hw/circuits/preamp/psu.net (led typ, V5 5)

.include /Users/roberto/EDA/.claude/worktrees/L41b1-temporizzatore-hw/models/diodes/1n4148.lib
.include /Users/roberto/EDA/.claude/worktrees/L41b1-temporizzatore-hw/models/mosfet_n/generic_nmos.lib
.include /Users/roberto/EDA/.claude/worktrees/L41b1-temporizzatore-hw/models/mosfet_p/generic_pmos.lib
.include /Users/roberto/EDA/.claude/worktrees/L41b1-temporizzatore-hw/models/bjt_npn/generic_npn.lib
.include /Users/roberto/EDA/.claude/worktrees/L41b1-temporizzatore-hw/models/bjt_pnp/generic_pnp.lib
* declared generic models (L41a): bridge diode, Schottky, 24 V zener; L41b1: BAT54
.model DBR D(Is=1e-9 N=1.8 Rs=0.03)
.model DSCH D(Is=1e-6 N=1.1 Rs=0.05)
.model DZ24 D(Is=1e-12 N=1 Rs=1 BV=24 IBV=1m)
.model DBAT54 D(Is=2e-8 N=1.05 Rs=1)
* the VTL5C4 LED (models/optocoupler/vtl5c4_comportamentale.lib; --led max: 2.0 V at 20 mA)
.model DLEDV D(IS=2.8e-16 N=2)

* behavioural positive / negative regulator: gm to VSET, clamped to [0, ILIM],
* dropout VDO, no reverse current, input current = output current + IQ
.subckt REGP in out gnd en VSET=15 VDO=0.3 ILIM=1 IQ=1m
Bo gnd out I = V(en)*min({ILIM}, max(0, 1000*(min({VSET}, V(in,gnd)-{VDO}) - V(out,gnd))))
Bi in gnd I = V(en)*min({ILIM}, max(0, 1000*(min({VSET}, V(in,gnd)-{VDO}) - V(out,gnd)))) + {IQ}*(V(in,gnd)>1)
Rl out gnd 1meg
.ends
.subckt REGM in out gnd en VSET=15 VDO=0.3 ILIM=1 IQ=1m
Bo out gnd I = V(en)*min({ILIM}, max(0, 1000*(min({VSET}, V(gnd,in)-{VDO}) - V(gnd,out))))
Bi gnd in I = V(en)*min({ILIM}, max(0, 1000*(min({VSET}, V(gnd,in)-{VDO}) - V(gnd,out)))) + {IQ}*(V(gnd,in)>1)
Rl out gnd 1meg
.ends
* behavioural open-drain comparator: output sinks when inn > inp, 1 us,
* high impedance with its supply below 2 V; 55 uA from its supply (L41b1)
.subckt CMPOD inp inn out vcc gnd
Bu u gnd V = 0.5*(1+tanh((V(inn)-V(inp))/1m)) * 0.5*(1+tanh((V(vcc,gnd)-2)/0.1))
Ru u uf 1k
Cu uf gnd 1n
Bs out gnd I = V(out,gnd)/50 * V(uf,gnd)
Rleak out gnd 1G
Bq vcc gnd I = 55u*(V(vcc,gnd)>1)
.ends
* behavioural LM4040-2.5 shunt
.subckt SHUNT25 k a
Bz k a I = max(0, V(k,a)-2.5)*20
.ends
* behavioural MCP6004 section: 1e5, pole 10 Hz (GBW 1 MHz), rails - 25 mV,
* +-23 mA, 100 uA; the internal node clamped to the rails (no wind-up)
.subckt OPA5 inp inn out vcc vee
Gin 0 n1 inp inn 1e-3
R1 n1 0 1e8
C1 n1 0 159p
Bcl n1 0 I = 0.1*ln(1+exp((V(n1)-V(vcc))/0.01)) - 0.1*ln(1+exp((V(vee)-V(n1))/0.01))
Bo o2 0 V = max(V(vee)+0.025, min(V(vcc)-0.025, V(n1)))
Bout 0 out I = max(-23m, min(23m, (V(o2)-V(out))/10))
Bq vcc vee I = 100u*(V(vcc,vee)>1)
.ends
* the same for the DC and noise decks, without the pole and with a smooth
* (tanh) saturation, so Newton converges: gain 1e5 at the centre, rails -25 mV
* (L41b1: the clamped version above sent every .op to the transient fallback)
.subckt OPA5DC inp inn out vcc vee
Bo o2 0 V = 0.5*(V(vcc)+V(vee)) + (0.5*V(vcc,vee)-0.025)*tanh(1e3*V(inp,inn)/(0.5*V(vcc,vee)-0.025))
Ro o2 out 10
Bq vcc vee I = 100u
.ends

* parts: C537 C538 C541 C542 J3 Q507 Q508 Q509 Q510 Q511 Q512 R548 R549 R550 R551 R552 R553 R554 R555 R556 R560 R561 R562 R563 R564 R565 R566 R567 R568 U510 U511
CC537 exp_f_s exp_n_s 10n
CC538 exp_x_s rly_ret 1u
CC541 exp_f_p exp_n_p 10n
CC542 exp_x_p rly_ret 1u
QQ507a exp_n_s vref exp_e_s QNGEN
QQ507b mir_s exp_b2_s exp_e_s QNGEN
QQ508a exp_n_p vref exp_e_p QNGEN
QQ508b mir_p exp_b2_p exp_e_p QNGEN
QQ509 exp_fc_s exp_f_s exp_e_s QPGEN
QQ510 exp_fc_p exp_f_p exp_e_p QPGEN
QQ511a mir_s mir_s mir_e1_s QPGEN
QQ511b ldr_s_a mir_s mir_e2_s QPGEN
QQ512a mir_p mir_p mir_e1_p QPGEN
QQ512b ldr_p_a mir_p mir_e2_p QPGEN
RR548 v5 exp_n_s 24.9k
RR549 exp_fc_s rly_ret 56
RR550 dac_s rly_ret 100k
RR551 dac_s exp_x_s 100k
RR552 vref exp_x_s 22.1k
RR553 v5 mir_e1_s 10
RR554 v5 mir_e2_s 10
RR555 ldr_s_k 0 10
RR556 ldr_s_k adc_i_s 47k
RR560 v5 exp_n_p 24.9k
RR561 exp_fc_p rly_ret 56
RR562 dac_p rly_ret 100k
RR563 dac_p exp_x_p 100k
RR564 vref exp_x_p 22.1k
RR565 v5 mir_e1_p 10
RR566 v5 mir_e2_p 10
RR567 ldr_p_k 0 10
RR568 ldr_p_k adc_i_p 47k
BU510s 0 dac_s I = V(den_s)*(V(dset_s) - V(dac_s,rly_ret))/10
RU510s_sh dac_s rly_ret 500k
BU510p 0 dac_p I = V(den_p)*(V(dset_p) - V(dac_p,rly_ret))/10
RU510p_sh dac_p rly_ret 500k
BU510q v5 rly_ret I = 3.3u + 206u*(V(den_s) + V(den_p))
XU511a vref exp_n_s exp_f_s v5 rly_ret OPA5DC
EU511b exp_b2_s 0 exp_x_s 0 1
XU511c vref exp_n_p exp_f_p v5 rly_ret OPA5DC
EU511d exp_b2_p 0 exp_x_p 0 1
VV5 v5 0 dc 5
VVREF vref 0 dc 2.5
VRET rly_ret 0 dc 0
VDEN_S den_s 0 dc 1
VDEN_P den_p 0 dc 1
VDSET_S dset_s 0 dc 0
VDSET_P dset_p 0 dc 0 ac 1
R_pin_adc_i_p adc_i_p 0 1G
R_pin_adc_i_s adc_i_s 0 1G
.nodeset v(exp_x_s)=2.3 v(exp_b2_s)=2.3 v(exp_e_s)=1.9 v(exp_n_s)=2.5 v(exp_f_s)=1.2 v(mir_s)=4.3
.nodeset v(exp_x_p)=2.3 v(exp_b2_p)=2.3 v(exp_e_p)=1.9 v(exp_n_p)=2.5 v(exp_f_p)=1.2 v(mir_p)=4.3
DLS1 ldr_s_a ls_mid DLEDV
DLS2 ls_mid ls_k DLEDV
VLS ls_k ldr_s_k 0
DLP1 ldr_p_a lp_mid DLEDV
DLP2 lp_mid lp_k DLEDV
VLP lp_k ldr_p_k 0
.options reltol=1e-5 abstol=1e-15 vntol=1e-8
.control
set numdgt=12
alter vdset_s = 3.226000
alter vdset_p = 1.236000
alter vden_s = 1
alter vden_p = 1
dc temp 15 15 1
echo PUNTO comp S d0 15 2.000000e-02 3226
print i(vls) i(vlp) v(mir_e2_s) v(ldr_s_a) v(mir_e2_p) v(ldr_p_a)
destroy all
alter vdset_s = 2.595000
alter vdset_p = 1.236000
alter vden_s = 1
alter vden_p = 1
dc temp 15 15 1
echo PUNTO comp S d0.1 15 2.000000e-04 2595
print i(vls) i(vlp) v(mir_e2_s) v(ldr_s_a) v(mir_e2_p) v(ldr_p_a)
destroy all
alter vdset_s = 2.074000
alter vdset_p = 1.236000
alter vden_s = 1
alter vden_p = 1
dc temp 15 15 1
echo PUNTO comp S d0.45 15 4.500000e-06 2074
print i(vls) i(vlp) v(mir_e2_s) v(ldr_s_a) v(mir_e2_p) v(ldr_p_a)
destroy all
alter vdset_s = 1.640000
alter vdset_p = 1.236000
alter vden_s = 1
alter vden_p = 1
dc temp 15 15 1
echo PUNTO comp S d0.75 15 1.900000e-07 1640
print i(vls) i(vlp) v(mir_e2_s) v(ldr_s_a) v(mir_e2_p) v(ldr_p_a)
destroy all
alter vdset_s = 1.236000
alter vdset_p = 1.236000
alter vden_s = 1
alter vden_p = 1
dc temp 15 15 1
echo PUNTO comp S riposo 15 1.000000e-08 1236
print i(vls) i(vlp) v(mir_e2_s) v(ldr_s_a) v(mir_e2_p) v(ldr_p_a)
destroy all
alter vdset_p = 1.236000
alter vdset_s = 1.236000
alter vden_s = 1
alter vden_p = 1
dc temp 15 15 1
echo PUNTO comp P riposo 15 1.000000e-08 1236
print i(vls) i(vlp) v(mir_e2_s) v(ldr_s_a) v(mir_e2_p) v(ldr_p_a)
destroy all
alter vdset_p = 2.231000
alter vdset_s = 1.236000
alter vden_s = 1
alter vden_p = 1
dc temp 15 15 1
echo PUNTO comp P d0.75 15 1.414214e-05 2231
print i(vls) i(vlp) v(mir_e2_s) v(ldr_s_a) v(mir_e2_p) v(ldr_p_a)
destroy all
alter vdset_p = 3.226000
alter vdset_s = 1.236000
alter vden_s = 1
alter vden_p = 1
dc temp 15 15 1
echo PUNTO comp P d1 15 2.000000e-02 3226
print i(vls) i(vlp) v(mir_e2_s) v(ldr_s_a) v(mir_e2_p) v(ldr_p_a)
destroy all
alter vdset_s = 2.910000
alter vdset_p = 1.236000
alter vden_s = 1
alter vden_p = 1
dc temp 15 15 1
echo PUNTO comp S cal_2mA 15 2.000000e-03 2910
print i(vls) i(vlp) v(mir_e2_s) v(ldr_s_a) v(mir_e2_p) v(ldr_p_a)
destroy all
alter vdset_p = 2.910000
alter vdset_s = 1.236000
alter vden_s = 1
alter vden_p = 1
dc temp 15 15 1
echo PUNTO comp P cal_2mA 15 2.000000e-03 2910
print i(vls) i(vlp) v(mir_e2_s) v(ldr_s_a) v(mir_e2_p) v(ldr_p_a)
destroy all
alter vdset_s = 3.252000
alter vdset_p = 1.192000
alter vden_s = 1
alter vden_p = 1
dc temp 15 15 1
echo PUNTO nocomp S d0 15 2.000000e-02 3252
print i(vls) i(vlp) v(mir_e2_s) v(ldr_s_a) v(mir_e2_p) v(ldr_p_a)
destroy all
alter vdset_s = 2.598000
alter vdset_p = 1.192000
alter vden_s = 1
alter vden_p = 1
dc temp 15 15 1
echo PUNTO nocomp S d0.1 15 2.000000e-04 2598
print i(vls) i(vlp) v(mir_e2_s) v(ldr_s_a) v(mir_e2_p) v(ldr_p_a)
destroy all
alter vdset_s = 2.059000
alter vdset_p = 1.192000
alter vden_s = 1
alter vden_p = 1
dc temp 15 15 1
echo PUNTO nocomp S d0.45 15 4.500000e-06 2059
print i(vls) i(vlp) v(mir_e2_s) v(ldr_s_a) v(mir_e2_p) v(ldr_p_a)
destroy all
alter vdset_s = 1.610000
alter vdset_p = 1.192000
alter vden_s = 1
alter vden_p = 1
dc temp 15 15 1
echo PUNTO nocomp S d0.75 15 1.900000e-07 1610
print i(vls) i(vlp) v(mir_e2_s) v(ldr_s_a) v(mir_e2_p) v(ldr_p_a)
destroy all
alter vdset_s = 1.192000
alter vdset_p = 1.192000
alter vden_s = 1
alter vden_p = 1
dc temp 15 15 1
echo PUNTO nocomp S riposo 15 1.000000e-08 1192
print i(vls) i(vlp) v(mir_e2_s) v(ldr_s_a) v(mir_e2_p) v(ldr_p_a)
destroy all
alter vdset_p = 1.192000
alter vdset_s = 1.192000
alter vden_s = 1
alter vden_p = 1
dc temp 15 15 1
echo PUNTO nocomp P riposo 15 1.000000e-08 1192
print i(vls) i(vlp) v(mir_e2_s) v(ldr_s_a) v(mir_e2_p) v(ldr_p_a)
destroy all
alter vdset_p = 2.222000
alter vdset_s = 1.192000
alter vden_s = 1
alter vden_p = 1
dc temp 15 15 1
echo PUNTO nocomp P d0.75 15 1.414214e-05 2222
print i(vls) i(vlp) v(mir_e2_s) v(ldr_s_a) v(mir_e2_p) v(ldr_p_a)
destroy all
alter vdset_p = 3.252000
alter vdset_s = 1.192000
alter vden_s = 1
alter vden_p = 1
dc temp 15 15 1
echo PUNTO nocomp P d1 15 2.000000e-02 3252
print i(vls) i(vlp) v(mir_e2_s) v(ldr_s_a) v(mir_e2_p) v(ldr_p_a)
destroy all
alter vdset_s = 2.925000
alter vdset_p = 1.192000
alter vden_s = 1
alter vden_p = 1
dc temp 15 15 1
echo PUNTO nocomp S cal_2mA 15 2.000000e-03 2925
print i(vls) i(vlp) v(mir_e2_s) v(ldr_s_a) v(mir_e2_p) v(ldr_p_a)
destroy all
alter vdset_p = 2.925000
alter vdset_s = 1.192000
alter vden_s = 1
alter vden_p = 1
dc temp 15 15 1
echo PUNTO nocomp P cal_2mA 15 2.000000e-03 2925
print i(vls) i(vlp) v(mir_e2_s) v(ldr_s_a) v(mir_e2_p) v(ldr_p_a)
destroy all
alter vdset_s = 3.252000
alter vdset_p = 1.192000
alter vden_s = 1
alter vden_p = 1
dc temp 25 25 1
echo PUNTO comp S d0 25 2.000000e-02 3252
print i(vls) i(vlp) v(mir_e2_s) v(ldr_s_a) v(mir_e2_p) v(ldr_p_a)
destroy all
alter vdset_s = 2.598000
alter vdset_p = 1.192000
alter vden_s = 1
alter vden_p = 1
dc temp 25 25 1
echo PUNTO comp S d0.1 25 2.000000e-04 2598
print i(vls) i(vlp) v(mir_e2_s) v(ldr_s_a) v(mir_e2_p) v(ldr_p_a)
destroy all
alter vdset_s = 2.059000
alter vdset_p = 1.192000
alter vden_s = 1
alter vden_p = 1
dc temp 25 25 1
echo PUNTO comp S d0.45 25 4.500000e-06 2059
print i(vls) i(vlp) v(mir_e2_s) v(ldr_s_a) v(mir_e2_p) v(ldr_p_a)
destroy all
alter vdset_s = 1.610000
alter vdset_p = 1.192000
alter vden_s = 1
alter vden_p = 1
dc temp 25 25 1
echo PUNTO comp S d0.75 25 1.900000e-07 1610
print i(vls) i(vlp) v(mir_e2_s) v(ldr_s_a) v(mir_e2_p) v(ldr_p_a)
destroy all
alter vdset_s = 1.192000
alter vdset_p = 1.192000
alter vden_s = 1
alter vden_p = 1
dc temp 25 25 1
echo PUNTO comp S riposo 25 1.000000e-08 1192
print i(vls) i(vlp) v(mir_e2_s) v(ldr_s_a) v(mir_e2_p) v(ldr_p_a)
destroy all
alter vdset_p = 1.192000
alter vdset_s = 1.192000
alter vden_s = 1
alter vden_p = 1
dc temp 25 25 1
echo PUNTO comp P riposo 25 1.000000e-08 1192
print i(vls) i(vlp) v(mir_e2_s) v(ldr_s_a) v(mir_e2_p) v(ldr_p_a)
destroy all
alter vdset_p = 2.222000
alter vdset_s = 1.192000
alter vden_s = 1
alter vden_p = 1
dc temp 25 25 1
echo PUNTO comp P d0.75 25 1.414214e-05 2222
print i(vls) i(vlp) v(mir_e2_s) v(ldr_s_a) v(mir_e2_p) v(ldr_p_a)
destroy all
alter vdset_p = 3.252000
alter vdset_s = 1.192000
alter vden_s = 1
alter vden_p = 1
dc temp 25 25 1
echo PUNTO comp P d1 25 2.000000e-02 3252
print i(vls) i(vlp) v(mir_e2_s) v(ldr_s_a) v(mir_e2_p) v(ldr_p_a)
destroy all
alter vdset_s = 2.925000
alter vdset_p = 1.192000
alter vden_s = 1
alter vden_p = 1
dc temp 25 25 1
echo PUNTO comp S cal_2mA 25 2.000000e-03 2925
print i(vls) i(vlp) v(mir_e2_s) v(ldr_s_a) v(mir_e2_p) v(ldr_p_a)
destroy all
alter vdset_p = 2.925000
alter vdset_s = 1.192000
alter vden_s = 1
alter vden_p = 1
dc temp 25 25 1
echo PUNTO comp P cal_2mA 25 2.000000e-03 2925
print i(vls) i(vlp) v(mir_e2_s) v(ldr_s_a) v(mir_e2_p) v(ldr_p_a)
destroy all
alter vdset_s = 3.252000
alter vdset_p = 1.192000
alter vden_s = 1
alter vden_p = 1
dc temp 25 25 1
echo PUNTO nocomp S d0 25 2.000000e-02 3252
print i(vls) i(vlp) v(mir_e2_s) v(ldr_s_a) v(mir_e2_p) v(ldr_p_a)
destroy all
alter vdset_s = 2.598000
alter vdset_p = 1.192000
alter vden_s = 1
alter vden_p = 1
dc temp 25 25 1
echo PUNTO nocomp S d0.1 25 2.000000e-04 2598
print i(vls) i(vlp) v(mir_e2_s) v(ldr_s_a) v(mir_e2_p) v(ldr_p_a)
destroy all
alter vdset_s = 2.059000
alter vdset_p = 1.192000
alter vden_s = 1
alter vden_p = 1
dc temp 25 25 1
echo PUNTO nocomp S d0.45 25 4.500000e-06 2059
print i(vls) i(vlp) v(mir_e2_s) v(ldr_s_a) v(mir_e2_p) v(ldr_p_a)
destroy all
alter vdset_s = 1.610000
alter vdset_p = 1.192000
alter vden_s = 1
alter vden_p = 1
dc temp 25 25 1
echo PUNTO nocomp S d0.75 25 1.900000e-07 1610
print i(vls) i(vlp) v(mir_e2_s) v(ldr_s_a) v(mir_e2_p) v(ldr_p_a)
destroy all
alter vdset_s = 1.192000
alter vdset_p = 1.192000
alter vden_s = 1
alter vden_p = 1
dc temp 25 25 1
echo PUNTO nocomp S riposo 25 1.000000e-08 1192
print i(vls) i(vlp) v(mir_e2_s) v(ldr_s_a) v(mir_e2_p) v(ldr_p_a)
destroy all
alter vdset_p = 1.192000
alter vdset_s = 1.192000
alter vden_s = 1
alter vden_p = 1
dc temp 25 25 1
echo PUNTO nocomp P riposo 25 1.000000e-08 1192
print i(vls) i(vlp) v(mir_e2_s) v(ldr_s_a) v(mir_e2_p) v(ldr_p_a)
destroy all
alter vdset_p = 2.222000
alter vdset_s = 1.192000
alter vden_s = 1
alter vden_p = 1
dc temp 25 25 1
echo PUNTO nocomp P d0.75 25 1.414214e-05 2222
print i(vls) i(vlp) v(mir_e2_s) v(ldr_s_a) v(mir_e2_p) v(ldr_p_a)
destroy all
alter vdset_p = 3.252000
alter vdset_s = 1.192000
alter vden_s = 1
alter vden_p = 1
dc temp 25 25 1
echo PUNTO nocomp P d1 25 2.000000e-02 3252
print i(vls) i(vlp) v(mir_e2_s) v(ldr_s_a) v(mir_e2_p) v(ldr_p_a)
destroy all
alter vdset_s = 2.925000
alter vdset_p = 1.192000
alter vden_s = 1
alter vden_p = 1
dc temp 25 25 1
echo PUNTO nocomp S cal_2mA 25 2.000000e-03 2925
print i(vls) i(vlp) v(mir_e2_s) v(ldr_s_a) v(mir_e2_p) v(ldr_p_a)
destroy all
alter vdset_p = 2.925000
alter vdset_s = 1.192000
alter vden_s = 1
alter vden_p = 1
dc temp 25 25 1
echo PUNTO nocomp P cal_2mA 25 2.000000e-03 2925
print i(vls) i(vlp) v(mir_e2_s) v(ldr_s_a) v(mir_e2_p) v(ldr_p_a)
destroy all
alter vdset_s = 3.277000
alter vdset_p = 1.148000
alter vden_s = 1
alter vden_p = 1
dc temp 35 35 1
echo PUNTO comp S d0 35 2.000000e-02 3277
print i(vls) i(vlp) v(mir_e2_s) v(ldr_s_a) v(mir_e2_p) v(ldr_p_a)
destroy all
alter vdset_s = 2.601000
alter vdset_p = 1.148000
alter vden_s = 1
alter vden_p = 1
dc temp 35 35 1
echo PUNTO comp S d0.1 35 2.000000e-04 2601
print i(vls) i(vlp) v(mir_e2_s) v(ldr_s_a) v(mir_e2_p) v(ldr_p_a)
destroy all
alter vdset_s = 2.044000
alter vdset_p = 1.148000
alter vden_s = 1
alter vden_p = 1
dc temp 35 35 1
echo PUNTO comp S d0.45 35 4.500000e-06 2044
print i(vls) i(vlp) v(mir_e2_s) v(ldr_s_a) v(mir_e2_p) v(ldr_p_a)
destroy all
alter vdset_s = 1.580000
alter vdset_p = 1.148000
alter vden_s = 1
alter vden_p = 1
dc temp 35 35 1
echo PUNTO comp S d0.75 35 1.900000e-07 1580
print i(vls) i(vlp) v(mir_e2_s) v(ldr_s_a) v(mir_e2_p) v(ldr_p_a)
destroy all
alter vdset_s = 1.148000
alter vdset_p = 1.148000
alter vden_s = 1
alter vden_p = 1
dc temp 35 35 1
echo PUNTO comp S riposo 35 1.000000e-08 1148
print i(vls) i(vlp) v(mir_e2_s) v(ldr_s_a) v(mir_e2_p) v(ldr_p_a)
destroy all
alter vdset_p = 1.148000
alter vdset_s = 1.148000
alter vden_s = 1
alter vden_p = 1
dc temp 35 35 1
echo PUNTO comp P riposo 35 1.000000e-08 1148
print i(vls) i(vlp) v(mir_e2_s) v(ldr_s_a) v(mir_e2_p) v(ldr_p_a)
destroy all
alter vdset_p = 2.212000
alter vdset_s = 1.148000
alter vden_s = 1
alter vden_p = 1
dc temp 35 35 1
echo PUNTO comp P d0.75 35 1.414214e-05 2212
print i(vls) i(vlp) v(mir_e2_s) v(ldr_s_a) v(mir_e2_p) v(ldr_p_a)
destroy all
alter vdset_p = 3.277000
alter vdset_s = 1.148000
alter vden_s = 1
alter vden_p = 1
dc temp 35 35 1
echo PUNTO comp P d1 35 2.000000e-02 3277
print i(vls) i(vlp) v(mir_e2_s) v(ldr_s_a) v(mir_e2_p) v(ldr_p_a)
destroy all
alter vdset_s = 2.939000
alter vdset_p = 1.148000
alter vden_s = 1
alter vden_p = 1
dc temp 35 35 1
echo PUNTO comp S cal_2mA 35 2.000000e-03 2939
print i(vls) i(vlp) v(mir_e2_s) v(ldr_s_a) v(mir_e2_p) v(ldr_p_a)
destroy all
alter vdset_p = 2.939000
alter vdset_s = 1.148000
alter vden_s = 1
alter vden_p = 1
dc temp 35 35 1
echo PUNTO comp P cal_2mA 35 2.000000e-03 2939
print i(vls) i(vlp) v(mir_e2_s) v(ldr_s_a) v(mir_e2_p) v(ldr_p_a)
destroy all
alter vdset_s = 3.252000
alter vdset_p = 1.192000
alter vden_s = 1
alter vden_p = 1
dc temp 35 35 1
echo PUNTO nocomp S d0 35 2.000000e-02 3252
print i(vls) i(vlp) v(mir_e2_s) v(ldr_s_a) v(mir_e2_p) v(ldr_p_a)
destroy all
alter vdset_s = 2.598000
alter vdset_p = 1.192000
alter vden_s = 1
alter vden_p = 1
dc temp 35 35 1
echo PUNTO nocomp S d0.1 35 2.000000e-04 2598
print i(vls) i(vlp) v(mir_e2_s) v(ldr_s_a) v(mir_e2_p) v(ldr_p_a)
destroy all
alter vdset_s = 2.059000
alter vdset_p = 1.192000
alter vden_s = 1
alter vden_p = 1
dc temp 35 35 1
echo PUNTO nocomp S d0.45 35 4.500000e-06 2059
print i(vls) i(vlp) v(mir_e2_s) v(ldr_s_a) v(mir_e2_p) v(ldr_p_a)
destroy all
alter vdset_s = 1.610000
alter vdset_p = 1.192000
alter vden_s = 1
alter vden_p = 1
dc temp 35 35 1
echo PUNTO nocomp S d0.75 35 1.900000e-07 1610
print i(vls) i(vlp) v(mir_e2_s) v(ldr_s_a) v(mir_e2_p) v(ldr_p_a)
destroy all
alter vdset_s = 1.192000
alter vdset_p = 1.192000
alter vden_s = 1
alter vden_p = 1
dc temp 35 35 1
echo PUNTO nocomp S riposo 35 1.000000e-08 1192
print i(vls) i(vlp) v(mir_e2_s) v(ldr_s_a) v(mir_e2_p) v(ldr_p_a)
destroy all
alter vdset_p = 1.192000
alter vdset_s = 1.192000
alter vden_s = 1
alter vden_p = 1
dc temp 35 35 1
echo PUNTO nocomp P riposo 35 1.000000e-08 1192
print i(vls) i(vlp) v(mir_e2_s) v(ldr_s_a) v(mir_e2_p) v(ldr_p_a)
destroy all
alter vdset_p = 2.222000
alter vdset_s = 1.192000
alter vden_s = 1
alter vden_p = 1
dc temp 35 35 1
echo PUNTO nocomp P d0.75 35 1.414214e-05 2222
print i(vls) i(vlp) v(mir_e2_s) v(ldr_s_a) v(mir_e2_p) v(ldr_p_a)
destroy all
alter vdset_p = 3.252000
alter vdset_s = 1.192000
alter vden_s = 1
alter vden_p = 1
dc temp 35 35 1
echo PUNTO nocomp P d1 35 2.000000e-02 3252
print i(vls) i(vlp) v(mir_e2_s) v(ldr_s_a) v(mir_e2_p) v(ldr_p_a)
destroy all
alter vdset_s = 2.925000
alter vdset_p = 1.192000
alter vden_s = 1
alter vden_p = 1
dc temp 35 35 1
echo PUNTO nocomp S cal_2mA 35 2.000000e-03 2925
print i(vls) i(vlp) v(mir_e2_s) v(ldr_s_a) v(mir_e2_p) v(ldr_p_a)
destroy all
alter vdset_p = 2.925000
alter vdset_s = 1.192000
alter vden_s = 1
alter vden_p = 1
dc temp 35 35 1
echo PUNTO nocomp P cal_2mA 35 2.000000e-03 2925
print i(vls) i(vlp) v(mir_e2_s) v(ldr_s_a) v(mir_e2_p) v(ldr_p_a)
destroy all
alter vdset_s = 3.302000
alter vdset_p = 1.104000
alter vden_s = 1
alter vden_p = 1
dc temp 45 45 1
echo PUNTO comp S d0 45 2.000000e-02 3302
print i(vls) i(vlp) v(mir_e2_s) v(ldr_s_a) v(mir_e2_p) v(ldr_p_a)
destroy all
alter vdset_s = 2.604000
alter vdset_p = 1.104000
alter vden_s = 1
alter vden_p = 1
dc temp 45 45 1
echo PUNTO comp S d0.1 45 2.000000e-04 2604
print i(vls) i(vlp) v(mir_e2_s) v(ldr_s_a) v(mir_e2_p) v(ldr_p_a)
destroy all
alter vdset_s = 2.030000
alter vdset_p = 1.104000
alter vden_s = 1
alter vden_p = 1
dc temp 45 45 1
echo PUNTO comp S d0.45 45 4.500000e-06 2030
print i(vls) i(vlp) v(mir_e2_s) v(ldr_s_a) v(mir_e2_p) v(ldr_p_a)
destroy all
alter vdset_s = 1.550000
alter vdset_p = 1.104000
alter vden_s = 1
alter vden_p = 1
dc temp 45 45 1
echo PUNTO comp S d0.75 45 1.900000e-07 1550
print i(vls) i(vlp) v(mir_e2_s) v(ldr_s_a) v(mir_e2_p) v(ldr_p_a)
destroy all
alter vdset_s = 1.104000
alter vdset_p = 1.104000
alter vden_s = 1
alter vden_p = 1
dc temp 45 45 1
echo PUNTO comp S riposo 45 1.000000e-08 1104
print i(vls) i(vlp) v(mir_e2_s) v(ldr_s_a) v(mir_e2_p) v(ldr_p_a)
destroy all
alter vdset_p = 1.104000
alter vdset_s = 1.104000
alter vden_s = 1
alter vden_p = 1
dc temp 45 45 1
echo PUNTO comp P riposo 45 1.000000e-08 1104
print i(vls) i(vlp) v(mir_e2_s) v(ldr_s_a) v(mir_e2_p) v(ldr_p_a)
destroy all
alter vdset_p = 2.203000
alter vdset_s = 1.104000
alter vden_s = 1
alter vden_p = 1
dc temp 45 45 1
echo PUNTO comp P d0.75 45 1.414214e-05 2203
print i(vls) i(vlp) v(mir_e2_s) v(ldr_s_a) v(mir_e2_p) v(ldr_p_a)
destroy all
alter vdset_p = 3.302000
alter vdset_s = 1.104000
alter vden_s = 1
alter vden_p = 1
dc temp 45 45 1
echo PUNTO comp P d1 45 2.000000e-02 3302
print i(vls) i(vlp) v(mir_e2_s) v(ldr_s_a) v(mir_e2_p) v(ldr_p_a)
destroy all
alter vdset_s = 2.953000
alter vdset_p = 1.104000
alter vden_s = 1
alter vden_p = 1
dc temp 45 45 1
echo PUNTO comp S cal_2mA 45 2.000000e-03 2953
print i(vls) i(vlp) v(mir_e2_s) v(ldr_s_a) v(mir_e2_p) v(ldr_p_a)
destroy all
alter vdset_p = 2.953000
alter vdset_s = 1.104000
alter vden_s = 1
alter vden_p = 1
dc temp 45 45 1
echo PUNTO comp P cal_2mA 45 2.000000e-03 2953
print i(vls) i(vlp) v(mir_e2_s) v(ldr_s_a) v(mir_e2_p) v(ldr_p_a)
destroy all
alter vdset_s = 3.252000
alter vdset_p = 1.192000
alter vden_s = 1
alter vden_p = 1
dc temp 45 45 1
echo PUNTO nocomp S d0 45 2.000000e-02 3252
print i(vls) i(vlp) v(mir_e2_s) v(ldr_s_a) v(mir_e2_p) v(ldr_p_a)
destroy all
alter vdset_s = 2.598000
alter vdset_p = 1.192000
alter vden_s = 1
alter vden_p = 1
dc temp 45 45 1
echo PUNTO nocomp S d0.1 45 2.000000e-04 2598
print i(vls) i(vlp) v(mir_e2_s) v(ldr_s_a) v(mir_e2_p) v(ldr_p_a)
destroy all
alter vdset_s = 2.059000
alter vdset_p = 1.192000
alter vden_s = 1
alter vden_p = 1
dc temp 45 45 1
echo PUNTO nocomp S d0.45 45 4.500000e-06 2059
print i(vls) i(vlp) v(mir_e2_s) v(ldr_s_a) v(mir_e2_p) v(ldr_p_a)
destroy all
alter vdset_s = 1.610000
alter vdset_p = 1.192000
alter vden_s = 1
alter vden_p = 1
dc temp 45 45 1
echo PUNTO nocomp S d0.75 45 1.900000e-07 1610
print i(vls) i(vlp) v(mir_e2_s) v(ldr_s_a) v(mir_e2_p) v(ldr_p_a)
destroy all
alter vdset_s = 1.192000
alter vdset_p = 1.192000
alter vden_s = 1
alter vden_p = 1
dc temp 45 45 1
echo PUNTO nocomp S riposo 45 1.000000e-08 1192
print i(vls) i(vlp) v(mir_e2_s) v(ldr_s_a) v(mir_e2_p) v(ldr_p_a)
destroy all
alter vdset_p = 1.192000
alter vdset_s = 1.192000
alter vden_s = 1
alter vden_p = 1
dc temp 45 45 1
echo PUNTO nocomp P riposo 45 1.000000e-08 1192
print i(vls) i(vlp) v(mir_e2_s) v(ldr_s_a) v(mir_e2_p) v(ldr_p_a)
destroy all
alter vdset_p = 2.222000
alter vdset_s = 1.192000
alter vden_s = 1
alter vden_p = 1
dc temp 45 45 1
echo PUNTO nocomp P d0.75 45 1.414214e-05 2222
print i(vls) i(vlp) v(mir_e2_s) v(ldr_s_a) v(mir_e2_p) v(ldr_p_a)
destroy all
alter vdset_p = 3.252000
alter vdset_s = 1.192000
alter vden_s = 1
alter vden_p = 1
dc temp 45 45 1
echo PUNTO nocomp P d1 45 2.000000e-02 3252
print i(vls) i(vlp) v(mir_e2_s) v(ldr_s_a) v(mir_e2_p) v(ldr_p_a)
destroy all
alter vdset_s = 2.925000
alter vdset_p = 1.192000
alter vden_s = 1
alter vden_p = 1
dc temp 45 45 1
echo PUNTO nocomp S cal_2mA 45 2.000000e-03 2925
print i(vls) i(vlp) v(mir_e2_s) v(ldr_s_a) v(mir_e2_p) v(ldr_p_a)
destroy all
alter vdset_p = 2.925000
alter vdset_s = 1.192000
alter vden_s = 1
alter vden_p = 1
dc temp 45 45 1
echo PUNTO nocomp P cal_2mA 45 2.000000e-03 2925
print i(vls) i(vlp) v(mir_e2_s) v(ldr_s_a) v(mir_e2_p) v(ldr_p_a)
destroy all
alter vdset_s = 3.340000
alter vdset_p = 1.038000
alter vden_s = 1
alter vden_p = 1
dc temp 60 60 1
echo PUNTO comp S d0 60 2.000000e-02 3340
print i(vls) i(vlp) v(mir_e2_s) v(ldr_s_a) v(mir_e2_p) v(ldr_p_a)
destroy all
alter vdset_s = 2.609000
alter vdset_p = 1.038000
alter vden_s = 1
alter vden_p = 1
dc temp 60 60 1
echo PUNTO comp S d0.1 60 2.000000e-04 2609
print i(vls) i(vlp) v(mir_e2_s) v(ldr_s_a) v(mir_e2_p) v(ldr_p_a)
destroy all
alter vdset_s = 2.007000
alter vdset_p = 1.038000
alter vden_s = 1
alter vden_p = 1
dc temp 60 60 1
echo PUNTO comp S d0.45 60 4.500000e-06 2007
print i(vls) i(vlp) v(mir_e2_s) v(ldr_s_a) v(mir_e2_p) v(ldr_p_a)
destroy all
alter vdset_s = 1.506000
alter vdset_p = 1.038000
alter vden_s = 1
alter vden_p = 1
dc temp 60 60 1
echo PUNTO comp S d0.75 60 1.900000e-07 1506
print i(vls) i(vlp) v(mir_e2_s) v(ldr_s_a) v(mir_e2_p) v(ldr_p_a)
destroy all
alter vdset_s = 1.038000
alter vdset_p = 1.038000
alter vden_s = 1
alter vden_p = 1
dc temp 60 60 1
echo PUNTO comp S riposo 60 1.000000e-08 1038
print i(vls) i(vlp) v(mir_e2_s) v(ldr_s_a) v(mir_e2_p) v(ldr_p_a)
destroy all
alter vdset_p = 1.038000
alter vdset_s = 1.038000
alter vden_s = 1
alter vden_p = 1
dc temp 60 60 1
echo PUNTO comp P riposo 60 1.000000e-08 1038
print i(vls) i(vlp) v(mir_e2_s) v(ldr_s_a) v(mir_e2_p) v(ldr_p_a)
destroy all
alter vdset_p = 2.189000
alter vdset_s = 1.038000
alter vden_s = 1
alter vden_p = 1
dc temp 60 60 1
echo PUNTO comp P d0.75 60 1.414214e-05 2189
print i(vls) i(vlp) v(mir_e2_s) v(ldr_s_a) v(mir_e2_p) v(ldr_p_a)
destroy all
alter vdset_p = 3.340000
alter vdset_s = 1.038000
alter vden_s = 1
alter vden_p = 1
dc temp 60 60 1
echo PUNTO comp P d1 60 2.000000e-02 3340
print i(vls) i(vlp) v(mir_e2_s) v(ldr_s_a) v(mir_e2_p) v(ldr_p_a)
destroy all
alter vdset_s = 2.975000
alter vdset_p = 1.038000
alter vden_s = 1
alter vden_p = 1
dc temp 60 60 1
echo PUNTO comp S cal_2mA 60 2.000000e-03 2975
print i(vls) i(vlp) v(mir_e2_s) v(ldr_s_a) v(mir_e2_p) v(ldr_p_a)
destroy all
alter vdset_p = 2.975000
alter vdset_s = 1.038000
alter vden_s = 1
alter vden_p = 1
dc temp 60 60 1
echo PUNTO comp P cal_2mA 60 2.000000e-03 2975
print i(vls) i(vlp) v(mir_e2_s) v(ldr_s_a) v(mir_e2_p) v(ldr_p_a)
destroy all
alter vdset_s = 3.252000
alter vdset_p = 1.192000
alter vden_s = 1
alter vden_p = 1
dc temp 60 60 1
echo PUNTO nocomp S d0 60 2.000000e-02 3252
print i(vls) i(vlp) v(mir_e2_s) v(ldr_s_a) v(mir_e2_p) v(ldr_p_a)
destroy all
alter vdset_s = 2.598000
alter vdset_p = 1.192000
alter vden_s = 1
alter vden_p = 1
dc temp 60 60 1
echo PUNTO nocomp S d0.1 60 2.000000e-04 2598
print i(vls) i(vlp) v(mir_e2_s) v(ldr_s_a) v(mir_e2_p) v(ldr_p_a)
destroy all
alter vdset_s = 2.059000
alter vdset_p = 1.192000
alter vden_s = 1
alter vden_p = 1
dc temp 60 60 1
echo PUNTO nocomp S d0.45 60 4.500000e-06 2059
print i(vls) i(vlp) v(mir_e2_s) v(ldr_s_a) v(mir_e2_p) v(ldr_p_a)
destroy all
alter vdset_s = 1.610000
alter vdset_p = 1.192000
alter vden_s = 1
alter vden_p = 1
dc temp 60 60 1
echo PUNTO nocomp S d0.75 60 1.900000e-07 1610
print i(vls) i(vlp) v(mir_e2_s) v(ldr_s_a) v(mir_e2_p) v(ldr_p_a)
destroy all
alter vdset_s = 1.192000
alter vdset_p = 1.192000
alter vden_s = 1
alter vden_p = 1
dc temp 60 60 1
echo PUNTO nocomp S riposo 60 1.000000e-08 1192
print i(vls) i(vlp) v(mir_e2_s) v(ldr_s_a) v(mir_e2_p) v(ldr_p_a)
destroy all
alter vdset_p = 1.192000
alter vdset_s = 1.192000
alter vden_s = 1
alter vden_p = 1
dc temp 60 60 1
echo PUNTO nocomp P riposo 60 1.000000e-08 1192
print i(vls) i(vlp) v(mir_e2_s) v(ldr_s_a) v(mir_e2_p) v(ldr_p_a)
destroy all
alter vdset_p = 2.222000
alter vdset_s = 1.192000
alter vden_s = 1
alter vden_p = 1
dc temp 60 60 1
echo PUNTO nocomp P d0.75 60 1.414214e-05 2222
print i(vls) i(vlp) v(mir_e2_s) v(ldr_s_a) v(mir_e2_p) v(ldr_p_a)
destroy all
alter vdset_p = 3.252000
alter vdset_s = 1.192000
alter vden_s = 1
alter vden_p = 1
dc temp 60 60 1
echo PUNTO nocomp P d1 60 2.000000e-02 3252
print i(vls) i(vlp) v(mir_e2_s) v(ldr_s_a) v(mir_e2_p) v(ldr_p_a)
destroy all
alter vdset_s = 2.925000
alter vdset_p = 1.192000
alter vden_s = 1
alter vden_p = 1
dc temp 60 60 1
echo PUNTO nocomp S cal_2mA 60 2.000000e-03 2925
print i(vls) i(vlp) v(mir_e2_s) v(ldr_s_a) v(mir_e2_p) v(ldr_p_a)
destroy all
alter vdset_p = 2.925000
alter vdset_s = 1.192000
alter vden_s = 1
alter vden_p = 1
dc temp 60 60 1
echo PUNTO nocomp P cal_2mA 60 2.000000e-03 2925
print i(vls) i(vlp) v(mir_e2_s) v(ldr_s_a) v(mir_e2_p) v(ldr_p_a)
destroy all
alter vden_s = 0
alter vden_p = 0
dc temp 15 15 1
echo PUNTO dac_reset S riposo 15 1.000000e-08 -1
print i(vls) i(vlp) v(mir_e2_s) v(ldr_s_a) v(mir_e2_p) v(ldr_p_a)
destroy all
alter vden_s = 0
alter vden_p = 0
dc temp 25 25 1
echo PUNTO dac_reset S riposo 25 1.000000e-08 -1
print i(vls) i(vlp) v(mir_e2_s) v(ldr_s_a) v(mir_e2_p) v(ldr_p_a)
destroy all
alter vden_s = 0
alter vden_p = 0
dc temp 35 35 1
echo PUNTO dac_reset S riposo 35 1.000000e-08 -1
print i(vls) i(vlp) v(mir_e2_s) v(ldr_s_a) v(mir_e2_p) v(ldr_p_a)
destroy all
alter vden_s = 0
alter vden_p = 0
dc temp 45 45 1
echo PUNTO dac_reset S riposo 45 1.000000e-08 -1
print i(vls) i(vlp) v(mir_e2_s) v(ldr_s_a) v(mir_e2_p) v(ldr_p_a)
destroy all
alter vden_s = 0
alter vden_p = 0
dc temp 60 60 1
echo PUNTO dac_reset S riposo 60 1.000000e-08 -1
print i(vls) i(vlp) v(mir_e2_s) v(ldr_s_a) v(mir_e2_p) v(ldr_p_a)
destroy all
alter vden_s = 1
alter vden_p = 1
.endc
.end
