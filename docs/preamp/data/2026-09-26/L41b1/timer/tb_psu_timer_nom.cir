* L41b1 tb_psu timer (nom) - GENERATED by genera_tb_psu.py from /Users/roberto/EDA/.claude/worktrees/L41b1-temporizzatore-hw/circuits/preamp/psu.net

.include /Users/roberto/EDA/.claude/worktrees/L41b1-temporizzatore-hw/models/diodes/1n4148.lib
.include /Users/roberto/EDA/.claude/worktrees/L41b1-temporizzatore-hw/models/mosfet_n/generic_nmos.lib
.include /Users/roberto/EDA/.claude/worktrees/L41b1-temporizzatore-hw/models/mosfet_p/generic_pmos.lib
.include /Users/roberto/EDA/.claude/worktrees/L41b1-temporizzatore-hw/models/bjt_npn/generic_npn.lib
.include /Users/roberto/EDA/.claude/worktrees/L41b1-temporizzatore-hw/models/bjt_pnp/generic_pnp.lib
* declared generic models (L41a): bridge diode, Schottky, 24 V zener; L41b1: BAT54
.model DBR D(Is=1e-9 N=1.8 Rs=0.03)
.model DSCH D(Is=1e-6 N=1.1 Rs=0.05)
.model DZ24 D(Is=1e-12 N=1 Rs=1 BV=24 IBV=1m)
.model DBAT54 D(Is=2e-8 N=1.05 Rs=1)
* the VTL5C4 LED (models/optocoupler/vtl5c4_comportamentale.lib; --led max: 2.0 V at 20 mA)
.model DLEDV D(IS=2.8e-16 N=2)

* behavioural positive / negative regulator: gm to VSET, clamped to [0, ILIM],
* dropout VDO, no reverse current, input current = output current + IQ
.subckt REGP in out gnd en VSET=15 VDO=0.3 ILIM=1 IQ=1m
Bo gnd out I = V(en)*min({ILIM}, max(0, 1000*(min({VSET}, V(in,gnd)-{VDO}) - V(out,gnd))))
Bi in gnd I = V(en)*min({ILIM}, max(0, 1000*(min({VSET}, V(in,gnd)-{VDO}) - V(out,gnd)))) + {IQ}*(V(in,gnd)>1)
Rl out gnd 1meg
.ends
.subckt REGM in out gnd en VSET=15 VDO=0.3 ILIM=1 IQ=1m
Bo out gnd I = V(en)*min({ILIM}, max(0, 1000*(min({VSET}, V(gnd,in)-{VDO}) - V(gnd,out))))
Bi gnd in I = V(en)*min({ILIM}, max(0, 1000*(min({VSET}, V(gnd,in)-{VDO}) - V(gnd,out)))) + {IQ}*(V(gnd,in)>1)
Rl out gnd 1meg
.ends
* behavioural open-drain comparator: output sinks when inn > inp, 1 us,
* high impedance with its supply below 2 V; 55 uA from its supply (L41b1)
.subckt CMPOD inp inn out vcc gnd
Bu u gnd V = 0.5*(1+tanh((V(inn)-V(inp))/1m)) * 0.5*(1+tanh((V(vcc,gnd)-2)/0.1))
Ru u uf 1k
Cu uf gnd 1n
Bs out gnd I = V(out,gnd)/50 * V(uf,gnd)
Rleak out gnd 1G
Bq vcc gnd I = 55u*(V(vcc,gnd)>1)
.ends
* behavioural LM4040-2.5 shunt
.subckt SHUNT25 k a
Bz k a I = max(0, V(k,a)-2.5)*20
.ends
* behavioural MCP6004 section: 1e5, pole 10 Hz (GBW 1 MHz), rails - 25 mV,
* +-23 mA, 100 uA; the internal node clamped to the rails (no wind-up)
.subckt OPA5 inp inn out vcc vee
Gin 0 n1 inp inn 1e-3
R1 n1 0 1e8
C1 n1 0 159p
Bcl n1 0 I = 0.1*ln(1+exp((V(n1)-V(vcc))/0.01)) - 0.1*ln(1+exp((V(vee)-V(n1))/0.01))
Bo o2 0 V = max(V(vee)+0.025, min(V(vcc)-0.025, V(n1)))
Bout 0 out I = max(-23m, min(23m, (V(o2)-V(out))/10))
Bq vcc vee I = 100u*(V(vcc,vee)>1)
.ends
* the same for the DC and noise decks, without the pole and with a smooth
* (tanh) saturation, so Newton converges: gain 1e5 at the centre, rails -25 mV
* (L41b1: the clamped version above sent every .op to the transient fallback)
.subckt OPA5DC inp inn out vcc vee
Bo o2 0 V = 0.5*(V(vcc)+V(vee)) + (0.5*V(vcc,vee)-0.025)*tanh(1e3*V(inp,inn)/(0.5*V(vcc,vee)-0.025))
Ro o2 out 10
Bq vcc vee I = 100u
.ends

CC501 raw_p c501_esr {0.8*4700u}
RC501_esr c501_esr 0 0.03
CC502 0 c502_esr {0.8*4700u}
RC502_esr c502_esr raw_m 0.03
CC505 vplus c505_esr {0.8*2200u}
RC505_esr c505_esr 0 0.03
CC506 0 c506_esr {0.8*2200u}
RC506_esr c506_esr vminus 0.03
CC507 nr_p 0 10u
CC508 0 nr_m 10u
CC509 raw_p 0 10u
CC510 0 raw_m 10u
CC511 vplus 0 10u
CC512 0 vminus 10u
CC513 vminus fb_m 10n
CC514 vref rly_ret 100n
CC515 sup_p rly_ret 1n
CC516 sup_m rly_ret 1n
CC517 v5 rly_ret 100n
CC518 md rly_ret 100n
CC519 v5 rly_ret 100n
CC520 raw_v c520_esr {0.8*4700u}
RC520_esr c520_esr rly_ret 0.03
CC521 nr_v rly_ret 10u
CC522 raw_v rly_ret 10u
CC523 vrelay_reg c523_esr {0.8*2200u}
RC523_esr c523_esr rly_ret 0.03
CC524 vrelay_reg rly_ret 1u
CC525 v5 rly_ret 1u
CC526 sup_vr rly_ret 1n
CC527 mute_g rly_ret 22n
CC528 permit_t rly_ret 100n
CC529 vr_t rly_ret 100n
CC530 v5 rly_ret 100n
CC531 sw_g vrelay_reg 100n
CC532 front_in rly_ret 100n
CC533 mute_sw_in rly_ret 100n
CC534 v5 rly_ret 100n
CC535 v5 rly_ret 100n
CC536 v5 rly_ret 100n
CC537 exp_f_s exp_n_s 10n
CC538 exp_x_s rly_ret 1u
CC541 exp_f_p exp_n_p 10n
CC542 exp_x_p rly_ret 1u
DD501a t1_sec_a raw_p DBR
DD501b t1_sec_b raw_p DBR
DD501c raw_m t1_sec_a DBR
DD501d raw_m t1_sec_b DBR
DD503a t2_sec_a rect_v DBR
DD503b t2_sec_b rect_v DBR
DD503c rly_ret t2_sec_a DBR
DD503d rly_ret t2_sec_b DBR
DD504 rect_v raw_v DSCH
DD505 mains_coil vrelay_reg D1N914
DD506 mute_cmd clamp_mute D1N914
DD507 vrelay clamp_mute DZ24
DD508 permit_cmd clamp_permit D1N914
DD509 vrelay clamp_permit DZ24
DD510 vplus raw_p DSCH
DD511 raw_m vminus DSCH
DD512 vrelay_reg raw_v DSCH
DD520 pt_a permit_t D1N914
DD521 pt_b permit_t D1N914
DD522 mute_g permit_g DBAT54
DD523 permit_t vr_t D1N914
DD524 ve_a vr_t D1N914
RF501 ac_l t2_pri_l 1m
RK501_coil vrelay_reg mains_coil 360
RNT501 rly_ret 0 1m
MQ501 mute_cmd mute_g rly_ret rly_ret MNGEN W=2000u L=1u
MQ502 permit_cmd permit_g rly_ret rly_ret MNGEN W=2000u L=1u
MQ503 mains_coil mains_g rly_ret rly_ret MNGEN W=2000u L=1u
QQ504 md md_b rly_ret QNGEN
MQ505 vrelay sw_g vrelay_reg vrelay_reg MPGEN W=28000u L=1u
MQ506 sw_d vr_g rly_ret rly_ret MNGEN W=2000u L=1u
QQ507a exp_n_s vref exp_e_s QNGEN
QQ507b mir_s exp_b2_s exp_e_s QNGEN
QQ508a exp_n_p vref exp_e_p QNGEN
QQ508b mir_p exp_b2_p exp_e_p QNGEN
QQ509 exp_fc_s exp_f_s exp_e_s QPGEN
QQ510 exp_fc_p exp_f_p exp_e_p QPGEN
QQ511a mir_s mir_s mir_e1_s QPGEN
QQ511b ldr_s_a mir_s mir_e2_s QPGEN
QQ512a mir_p mir_p mir_e1_p QPGEN
QQ512b ldr_p_a mir_p mir_e2_p QPGEN
RR501 vminus fb_m 118k
RR502 fb_m 0 10k
RR503 v5 vref 2k
RR504 vref vref_half 10k
RR505 vref_half rly_ret 10k
RR506 vplus sup_p 44.2k
RR507 sup_p rly_ret 10k
RR508 vref sup_m 10k
RR509 sup_m vminus 118k
RR510 rect_v md_b 22k
RR511 md_b rly_ret 4.7k
RR512 v5 md 220k
RR513 mute_req mute_g 10k
RR514 mute_g rly_ret 100k
RR516 permit_g rly_ret 100k
RR517 v5 mute_sw 100k
RR518 v5 front_sw 100k
RR520 mains_req mains_g 10k
RR521 mains_g rly_ret 100k
RR522 vrelay_reg sup_vr 34k
RR523 sup_vr rly_ret 10k
RR524 v5 permit_g 10k
RR525 mute_req rly_ret 100k
RR526 permit_req rly_ret 100k
RR527 vrelay_en rly_ret 100k
RR528 mains_req rly_ret 100k
RR532 mute_req pt_a 1k
RR533 permit_req pt_b 1k
RR534 permit_t rly_ret 332k
RR535 vrelay_en ve_a 1k
RR536 vr_t rly_ret 1MEG
RR537 v5 vr_g 10k
RR538 vr_g rly_ret 100k
RR539 sw_d sw_g 47k
RR540 sw_g vrelay_reg 100k
RR541 front_sw front_in 1k
RR542 mute_sw mute_sw_in 1k
RR543 mute_g mute_g_in 1MEG
RR544 sup_p adc_sup_p 47k
RR545 sup_m adc_sup_m 47k
RR546 sup_vr adc_sup_vr 47k
RR547 md adc_md 47k
RR548 v5 exp_n_s 24.9k
RR549 exp_fc_s rly_ret 56
RR550 dac_s rly_ret 100k
RR551 dac_s exp_x_s 100k
RR552 vref exp_x_s 22.1k
RR553 v5 mir_e1_s 10
RR554 v5 mir_e2_s 10
RR555 ldr_s_k 0 10
RR556 ldr_s_k adc_i_s 47k
RR560 v5 exp_n_p 24.9k
RR561 exp_fc_p rly_ret 56
RR562 dac_p rly_ret 100k
RR563 dac_p exp_x_p 100k
RR564 vref exp_x_p 22.1k
RR565 v5 mir_e1_p 10
RR566 v5 mir_e2_p 10
RR567 ldr_p_k 0 10
RR568 ldr_p_k adc_i_p 47k
XU501 raw_p vplus 0 en_u501 REGP VSET=15 VDO=0.3 ILIM=1 IQ=0.58m
VENU501 en_u501 0 pwl(0 1 1000 1)
XU502 raw_m vminus 0 en_u502 REGM VSET=15.0528 VDO=0.3 ILIM=1 IQ=1m
VENU502 en_u502 0 pwl(0 1 1000 1)
XU503 raw_v vrelay_reg rly_ret en_u503 REGP VSET=12 VDO=0.3 ILIM=1 IQ=0.58m
VENU503 en_u503 0 pwl(0 1 1000 1)
XU504 vrelay_reg v5 rly_ret en_u504 REGP VSET=5 VDO=0.6 ILIM=0.25 IQ=2u
VENU504 en_u504 0 pwl(0 1 1000 1)
XU505a sup_p vref mute_g v5 rly_ret CMPOD
XU505b vref_half sup_m mute_g v5 rly_ret CMPOD
XU506a vref md mute_g v5 rly_ret CMPOD
XU506b sup_vr vref mute_g v5 rly_ret CMPOD
XU507 vref rly_ret SHUNT25
XU508a permit_t vref permit_g v5 rly_ret CMPOD
XU508b vr_t vref vr_g v5 rly_ret CMPOD
BU509q v5 rly_ret I = V(iq_mcu)
BU509_10 0 permit_req I = V(drv_permit_req)*(V(set_permit_req)*V(v5,rly_ret) - V(permit_req,rly_ret))/50
BU509_11 0 mute_req I = V(drv_mute_req)*(V(set_mute_req)*V(v5,rly_ret) - V(mute_req,rly_ret))/50
RU509_12 front_in rly_ret 1G
RU509_13 mute_sw_in rly_ret 1G
RU509_14 mute_g_in rly_ret 1G
RU509_16 updi rly_ret 1G
RU509_17 dac_sdi rly_ret 1G
RU509_18 adc_i_p rly_ret 1G
RU509_19 dac_sck rly_ret 1G
RU509_2 dac_cs rly_ret 1G
RU509_3 adc_sup_p rly_ret 1G
RU509_4 adc_sup_m rly_ret 1G
RU509_5 adc_sup_vr rly_ret 1G
RU509_6 adc_md rly_ret 1G
RU509_7 adc_i_s rly_ret 1G
BU509_8 0 vrelay_en I = V(drv_vrelay_en)*(V(set_vrelay_en)*V(v5,rly_ret) - V(vrelay_en,rly_ret))/50
BU509_9 0 mains_req I = V(drv_mains_req)*(V(set_mains_req)*V(v5,rly_ret) - V(mains_req,rly_ret))/50
BU510s 0 dac_s I = V(den_s)*(V(dset_s) - V(dac_s,rly_ret))/10
RU510s_sh dac_s rly_ret 500k
BU510p 0 dac_p I = V(den_p)*(V(dset_p) - V(dac_p,rly_ret))/10
RU510p_sh dac_p rly_ret 500k
BU510q v5 rly_ret I = 3.3u + 206u*(V(den_s) + V(den_p))
XU511a vref exp_n_s exp_f_s v5 rly_ret OPA5
XU511b exp_x_s exp_b2_s exp_b2_s v5 rly_ret OPA5
XU511c vref exp_n_p exp_f_p v5 rly_ret OPA5
XU511d exp_x_p exp_b2_p exp_b2_p v5 rly_ret OPA5
R_float_ac_l ac_l 0 1G
R_float_ac_n ac_n 0 1G
R_float_t1_pri_l t1_pri_l 0 1G
R_float_t1_pri_n t1_pri_n 0 1G
R_float_t2_pri_l t2_pri_l 0 1G
VENV env 0 pwl(0 1 1000 1)
VENV1 env1 0 pwl(0 1 1000 1)
BT1_SEC_Aa T1_SEC_Aa_e 0 V = V(env1)*22.9103*sin(2*pi*50*time)
VT1a_sns T1_SEC_Aa_e T1_SEC_Aa_i 0
BT1_SEC_Ab 0 T1_SEC_Ab_e V = V(env1)*22.9103*sin(2*pi*50*time)
VT1b_sns T1_SEC_Ab_e T1_SEC_Ab_i 0
RT1_SEC_Aa T1_SEC_Aa_i T1_SEC_Aa_l 0.7200
LT1_SEC_Aa T1_SEC_Aa_l t1_sec_a 100u
RT1_SEC_Ab T1_SEC_Ab_i T1_SEC_Ab_l 0.7200
LT1_SEC_Ab T1_SEC_Ab_l t1_sec_b 100u
BT2_SEC_A T2_SEC_A_e t2_sec_b V = V(env)*20.3647*sin(2*pi*50*time)
VT2_sns T2_SEC_A_e T2_SEC_A_i 0
RT2_SEC_A T2_SEC_A_i T2_SEC_A_l 5.7600
LT2_SEC_A T2_SEC_A_l t2_sec_a 100u
RT2_SEC_A_float t2_sec_b 0 10meg
VSET_mute_req set_mute_req 0 pwl(0 0 1 0 1.0001 1 1000 1)
VDRV_mute_req drv_mute_req 0 pwl(0 1 1000 1)
VSET_permit_req set_permit_req 0 pwl(0 0 1 0 1.0001 1 1000 1)
VDRV_permit_req drv_permit_req 0 pwl(0 1 1000 1)
VSET_mains_req set_mains_req 0 pwl(0 1 1000 1)
VDRV_mains_req drv_mains_req 0 pwl(0 1 1000 1)
VSET_vrelay_en set_vrelay_en 0 pwl(0 0 0.9 0 0.9001 1 1000 1)
VDRV_vrelay_en drv_vrelay_en 0 pwl(0 1 1000 1)
VIQ iq_mcu 0 pwl(0 2m 1000 2m)
VDEN_S den_s 0 pwl(0 1 1000 1)
VDEN_P den_p 0 pwl(0 1 1000 1)
VDSET_S dset_s 0 dc 3.252000
VDSET_P dset_p 0 dc 1.192000
IPLUS vplus 0 dc 0 pwl(0 0 0.5 0.265)
IMINUS 0 vminus dc 0 pwl(0 0 0.5 0.265)
RMUTECOIL vrelay mute_cmd 438.333
RPERMITCOIL vrelay permit_cmd 1315
RRESTO vrelay rly_ret 283.019
BTRIM vrelay rly_ret I = 0.0364*max(0, V(vrelay,rly_ret))/12*0.5*(1+tanh((V(permit_cmd,rly_ret)-6)/0.5))
DLS1 ldr_s_a ls_mid DLEDV
DLS2 ls_mid ldr_s_k DLEDV
DLP1 ldr_p_a lp_mid DLEDV
DLP2 lp_mid ldr_p_k DLEDV
RSW3 mute_sw rly_ret 1
RFRONT front_sw rly_ret 1
.options reltol=1e-4 abstol=1e-10 vntol=1e-6
.control
set numdgt=15
* ---- micro_reset ----
alter @venv[pwl] = [ 0 1 1000 1 ]
alter @venv1[pwl] = [ 0 1 1000 1 ]
alter @viq[pwl] = [ 0 2m 1000 2m ]
alter @vden_s[pwl] = [ 0 1 1000 1 ]
alter @vden_p[pwl] = [ 0 1 1000 1 ]
alter rfront = 1
alter @venu501[pwl] = [ 0 1 1000 1 ]
alter @venu502[pwl] = [ 0 1 1000 1 ]
alter @venu503[pwl] = [ 0 1 1000 1 ]
alter @venu504[pwl] = [ 0 1 1000 1 ]
alter cc528 = 1e-07
alter @vset_mute_req[pwl] = [ 0 0 1 0 1.0001 1 1000 1 ]
alter @vdrv_mute_req[pwl] = [ 0 1 2 1 2.000001 0 1000 0 ]
alter @vset_permit_req[pwl] = [ 0 0 1 0 1.0001 1 1000 1 ]
alter @vdrv_permit_req[pwl] = [ 0 1 2 1 2.000001 0 1000 0 ]
alter @vset_mains_req[pwl] = [ 0 1 1000 1 ]
alter @vdrv_mains_req[pwl] = [ 0 1 2 1 2.000001 0 1000 0 ]
alter @vset_vrelay_en[pwl] = [ 0 0 0.9 0 0.9001 1 1000 1 ]
alter @vdrv_vrelay_en[pwl] = [ 0 1 2 1 2.000001 0 1000 0 ]
echo CASO micro_reset
print @cc528[capacitance]
tran 20u 2.2 0 20u uic
meas tran t_mute WHEN v(mute_cmd)=6 RISE=1 FROM=2
meas tran t_permit WHEN v(permit_cmd)=6 RISE=1 FROM=2
meas tran t_vr80 WHEN v(vrelay)=9.6 FALL=1 FROM=2
meas tran t_mute_g WHEN v(mute_g)=1.0 FALL=1 FROM=2
meas tran vrelay_min MIN v(vrelay) FROM=2 TO=2.19
destroy all
* ---- micro_a_zero ----
alter @venv[pwl] = [ 0 1 1000 1 ]
alter @venv1[pwl] = [ 0 1 1000 1 ]
alter @viq[pwl] = [ 0 2m 1000 2m ]
alter @vden_s[pwl] = [ 0 1 1000 1 ]
alter @vden_p[pwl] = [ 0 1 1000 1 ]
alter rfront = 1
alter @venu501[pwl] = [ 0 1 1000 1 ]
alter @venu502[pwl] = [ 0 1 1000 1 ]
alter @venu503[pwl] = [ 0 1 1000 1 ]
alter @venu504[pwl] = [ 0 1 1000 1 ]
alter cc528 = 1e-07
alter @vset_mute_req[pwl] = [ 0 0 1 0 1.0001 1 2 1 2.000001 0 1000 0 ]
alter @vdrv_mute_req[pwl] = [ 0 1 1000 1 ]
alter @vset_permit_req[pwl] = [ 0 0 1 0 1.0001 1 2 1 2.000001 0 1000 0 ]
alter @vdrv_permit_req[pwl] = [ 0 1 1000 1 ]
alter @vset_mains_req[pwl] = [ 0 1 1000 1 ]
alter @vdrv_mains_req[pwl] = [ 0 1 1000 1 ]
alter @vset_vrelay_en[pwl] = [ 0 0 1 0 1.0001 1 2 1 2.000001 0 1000 0 ]
alter @vdrv_vrelay_en[pwl] = [ 0 1 1000 1 ]
echo CASO micro_a_zero
print @cc528[capacitance]
tran 20u 2.2 0 20u uic
meas tran t_mute WHEN v(mute_cmd)=6 RISE=1 FROM=2
meas tran t_permit WHEN v(permit_cmd)=6 RISE=1 FROM=2
meas tran t_vr80 WHEN v(vrelay)=9.6 FALL=1 FROM=2
meas tran t_mute_g WHEN v(mute_g)=1.0 FALL=1 FROM=2
meas tran vrelay_min MIN v(vrelay) FROM=2 TO=2.19
destroy all
* ---- solo_permit_req_giu ----
alter @venv[pwl] = [ 0 1 1000 1 ]
alter @venv1[pwl] = [ 0 1 1000 1 ]
alter @viq[pwl] = [ 0 2m 1000 2m ]
alter @vden_s[pwl] = [ 0 1 1000 1 ]
alter @vden_p[pwl] = [ 0 1 1000 1 ]
alter rfront = 1
alter @venu501[pwl] = [ 0 1 1000 1 ]
alter @venu502[pwl] = [ 0 1 1000 1 ]
alter @venu503[pwl] = [ 0 1 1000 1 ]
alter @venu504[pwl] = [ 0 1 1000 1 ]
alter cc528 = 1e-07
alter @vset_mute_req[pwl] = [ 0 0 1 0 1.0001 1 1000 1 ]
alter @vdrv_mute_req[pwl] = [ 0 1 1000 1 ]
alter @vset_permit_req[pwl] = [ 0 0 1 0 1.0001 1 2 1 2.000001 0 1000 0 ]
alter @vdrv_permit_req[pwl] = [ 0 1 1000 1 ]
alter @vset_mains_req[pwl] = [ 0 1 1000 1 ]
alter @vdrv_mains_req[pwl] = [ 0 1 1000 1 ]
alter @vset_vrelay_en[pwl] = [ 0 0 0.9 0 0.9001 1 1000 1 ]
alter @vdrv_vrelay_en[pwl] = [ 0 1 1000 1 ]
echo CASO solo_permit_req_giu
print @cc528[capacitance]
tran 20u 2.1 0 20u uic
meas tran permit_max MAX v(permit_cmd) FROM=2 TO=2.1
meas tran mute_max MAX v(mute_cmd) FROM=2 TO=2.1
destroy all
* ---- perdita_rete_micro_fermo_alto ----
alter @venv[pwl] = [ 0 1 2 1 2.0001 0 1000 0 ]
alter @venv1[pwl] = [ 0 1 2 1 2.0001 0 1000 0 ]
alter @viq[pwl] = [ 0 2m 1000 2m ]
alter @vden_s[pwl] = [ 0 1 1000 1 ]
alter @vden_p[pwl] = [ 0 1 1000 1 ]
alter rfront = 1
alter @venu501[pwl] = [ 0 1 1000 1 ]
alter @venu502[pwl] = [ 0 1 1000 1 ]
alter @venu503[pwl] = [ 0 1 1000 1 ]
alter @venu504[pwl] = [ 0 1 1000 1 ]
alter cc528 = 1e-07
alter @vset_mute_req[pwl] = [ 0 0 1 0 1.0001 1 1000 1 ]
alter @vdrv_mute_req[pwl] = [ 0 1 1000 1 ]
alter @vset_permit_req[pwl] = [ 0 0 1 0 1.0001 1 1000 1 ]
alter @vdrv_permit_req[pwl] = [ 0 1 1000 1 ]
alter @vset_mains_req[pwl] = [ 0 1 1000 1 ]
alter @vdrv_mains_req[pwl] = [ 0 1 1000 1 ]
alter @vset_vrelay_en[pwl] = [ 0 0 0.9 0 0.9001 1 1000 1 ]
alter @vdrv_vrelay_en[pwl] = [ 0 1 1000 1 ]
echo CASO perdita_rete_micro_fermo_alto
print @cc528[capacitance]
tran 20u 2.4 0 20u uic
meas tran t_mute WHEN v(mute_cmd)=6 RISE=1 FROM=2
meas tran t_permit WHEN v(permit_cmd)=6 RISE=1 FROM=2
meas tran t_vr80 WHEN v(vrelay)=9.6 FALL=1 FROM=2
meas tran t_mute_g WHEN v(mute_g)=1.0 FALL=1 FROM=2
meas tran vrelay_min MIN v(vrelay) FROM=2 TO=2.39
destroy all
* ---- perdita_rete_micro_reset ----
alter @venv[pwl] = [ 0 1 2 1 2.0001 0 1000 0 ]
alter @venv1[pwl] = [ 0 1 2 1 2.0001 0 1000 0 ]
alter @viq[pwl] = [ 0 2m 1000 2m ]
alter @vden_s[pwl] = [ 0 1 1000 1 ]
alter @vden_p[pwl] = [ 0 1 1000 1 ]
alter rfront = 1
alter @venu501[pwl] = [ 0 1 1000 1 ]
alter @venu502[pwl] = [ 0 1 1000 1 ]
alter @venu503[pwl] = [ 0 1 1000 1 ]
alter @venu504[pwl] = [ 0 1 1000 1 ]
alter cc528 = 1e-07
alter @vset_mute_req[pwl] = [ 0 0 1 0 1.0001 1 1000 1 ]
alter @vdrv_mute_req[pwl] = [ 0 1 2 1 2.000001 0 1000 0 ]
alter @vset_permit_req[pwl] = [ 0 0 1 0 1.0001 1 1000 1 ]
alter @vdrv_permit_req[pwl] = [ 0 1 2 1 2.000001 0 1000 0 ]
alter @vset_mains_req[pwl] = [ 0 1 1000 1 ]
alter @vdrv_mains_req[pwl] = [ 0 1 2 1 2.000001 0 1000 0 ]
alter @vset_vrelay_en[pwl] = [ 0 0 0.9 0 0.9001 1 1000 1 ]
alter @vdrv_vrelay_en[pwl] = [ 0 1 2 1 2.000001 0 1000 0 ]
echo CASO perdita_rete_micro_reset
print @cc528[capacitance]
tran 20u 2.4 0 20u uic
meas tran t_mute WHEN v(mute_cmd)=6 RISE=1 FROM=2
meas tran t_permit WHEN v(permit_cmd)=6 RISE=1 FROM=2
meas tran t_vr80 WHEN v(vrelay)=9.6 FALL=1 FROM=2
meas tran t_mute_g WHEN v(mute_g)=1.0 FALL=1 FROM=2
meas tran vrelay_min MIN v(vrelay) FROM=2 TO=2.19
destroy all
* ---- guasto_U503_micro_reset ----
alter @venv[pwl] = [ 0 1 1000 1 ]
alter @venv1[pwl] = [ 0 1 1000 1 ]
alter @viq[pwl] = [ 0 2m 1000 2m ]
alter @vden_s[pwl] = [ 0 1 1000 1 ]
alter @vden_p[pwl] = [ 0 1 1000 1 ]
alter rfront = 1
alter @venu501[pwl] = [ 0 1 1000 1 ]
alter @venu502[pwl] = [ 0 1 1000 1 ]
alter @venu503[pwl] = [ 0 1 1000 1 ]
alter @venu504[pwl] = [ 0 1 1000 1 ]
alter cc528 = 1e-07
alter @vset_mute_req[pwl] = [ 0 0 1 0 1.0001 1 1000 1 ]
alter @vdrv_mute_req[pwl] = [ 0 1 2 1 2.000001 0 1000 0 ]
alter @vset_permit_req[pwl] = [ 0 0 1 0 1.0001 1 1000 1 ]
alter @vdrv_permit_req[pwl] = [ 0 1 2 1 2.000001 0 1000 0 ]
alter @vset_mains_req[pwl] = [ 0 1 1000 1 ]
alter @vdrv_mains_req[pwl] = [ 0 1 2 1 2.000001 0 1000 0 ]
alter @vset_vrelay_en[pwl] = [ 0 0 0.9 0 0.9001 1 1000 1 ]
alter @vdrv_vrelay_en[pwl] = [ 0 1 2 1 2.000001 0 1000 0 ]
alter @venu503[pwl] = [ 0 1 2 1 2.000001 0 1000 0 ]
echo CASO guasto_U503_micro_reset
print @cc528[capacitance]
tran 20u 2.3 0 20u uic
meas tran t_mute WHEN v(mute_cmd)=6 RISE=1 FROM=2
meas tran t_permit WHEN v(permit_cmd)=6 RISE=1 FROM=2
meas tran t_vr80 WHEN v(vrelay)=9.6 FALL=1 FROM=2
meas tran t_mute_g WHEN v(mute_g)=1.0 FALL=1 FROM=2
meas tran vrelay_min MIN v(vrelay) FROM=2 TO=2.19
destroy all
* ---- rilascio_solo_mute_req ----
alter @venv[pwl] = [ 0 1 1000 1 ]
alter @venv1[pwl] = [ 0 1 1000 1 ]
alter @viq[pwl] = [ 0 2m 1000 2m ]
alter @vden_s[pwl] = [ 0 1 1000 1 ]
alter @vden_p[pwl] = [ 0 1 1000 1 ]
alter rfront = 1
alter @venu501[pwl] = [ 0 1 1000 1 ]
alter @venu502[pwl] = [ 0 1 1000 1 ]
alter @venu503[pwl] = [ 0 1 1000 1 ]
alter @venu504[pwl] = [ 0 1 1000 1 ]
alter cc528 = 1e-07
alter @vset_mute_req[pwl] = [ 0 0 2 0 2.000001 1 1000 1 ]
alter @vdrv_mute_req[pwl] = [ 0 1 1000 1 ]
alter @vset_permit_req[pwl] = [ 0 0 1000 0 ]
alter @vdrv_permit_req[pwl] = [ 0 1 1000 1 ]
alter @vset_mains_req[pwl] = [ 0 1 1000 1 ]
alter @vdrv_mains_req[pwl] = [ 0 1 1000 1 ]
alter @vset_vrelay_en[pwl] = [ 0 0 0.9 0 0.9001 1 1000 1 ]
alter @vdrv_vrelay_en[pwl] = [ 0 1 1000 1 ]
echo CASO rilascio_solo_mute_req
print @cc528[capacitance]
tran 20u 2.1 0 20u uic
meas tran t_mute_on WHEN v(mute_cmd)=6 FALL=1 FROM=2
meas tran t_permit_on WHEN v(permit_cmd)=6 FALL=1 FROM=2
destroy all
* ---- controfattuale_senza_C528 ----
alter @venv[pwl] = [ 0 1 1000 1 ]
alter @venv1[pwl] = [ 0 1 1000 1 ]
alter @viq[pwl] = [ 0 2m 1000 2m ]
alter @vden_s[pwl] = [ 0 1 1000 1 ]
alter @vden_p[pwl] = [ 0 1 1000 1 ]
alter rfront = 1
alter @venu501[pwl] = [ 0 1 1000 1 ]
alter @venu502[pwl] = [ 0 1 1000 1 ]
alter @venu503[pwl] = [ 0 1 1000 1 ]
alter @venu504[pwl] = [ 0 1 1000 1 ]
alter cc528 = 1e-07
alter @vset_mute_req[pwl] = [ 0 0 1 0 1.0001 1 1000 1 ]
alter @vdrv_mute_req[pwl] = [ 0 1 2 1 2.000001 0 1000 0 ]
alter @vset_permit_req[pwl] = [ 0 0 1 0 1.0001 1 1000 1 ]
alter @vdrv_permit_req[pwl] = [ 0 1 2 1 2.000001 0 1000 0 ]
alter @vset_mains_req[pwl] = [ 0 1 1000 1 ]
alter @vdrv_mains_req[pwl] = [ 0 1 2 1 2.000001 0 1000 0 ]
alter @vset_vrelay_en[pwl] = [ 0 0 0.9 0 0.9001 1 1000 1 ]
alter @vdrv_vrelay_en[pwl] = [ 0 1 2 1 2.000001 0 1000 0 ]
alter cc528 = 10p
echo CASO controfattuale_senza_C528
print @cc528[capacitance]
tran 20u 2.2 0 20u uic
meas tran t_mute WHEN v(mute_cmd)=6 RISE=1 FROM=2
meas tran t_permit WHEN v(permit_cmd)=6 RISE=1 FROM=2
meas tran t_vr80 WHEN v(vrelay)=9.6 FALL=1 FROM=2
meas tran t_mute_g WHEN v(mute_g)=1.0 FALL=1 FROM=2
meas tran vrelay_min MIN v(vrelay) FROM=2 TO=2.19
destroy all
* ---- standby ----
alter @venv[pwl] = [ 0 1 1000 1 ]
alter @venv1[pwl] = [ 0 0 1000 0 ]
alter @viq[pwl] = [ 0 5u 1000 5u ]
alter @vden_s[pwl] = [ 0 0 1000 0 ]
alter @vden_p[pwl] = [ 0 0 1000 0 ]
alter rfront = 1e+09
alter @venu501[pwl] = [ 0 1 1000 1 ]
alter @venu502[pwl] = [ 0 1 1000 1 ]
alter @venu503[pwl] = [ 0 1 1000 1 ]
alter @venu504[pwl] = [ 0 1 1000 1 ]
alter cc528 = 1e-07
alter @vset_mute_req[pwl] = [ 0 0 1000 0 ]
alter @vdrv_mute_req[pwl] = [ 0 1 1000 1 ]
alter @vset_permit_req[pwl] = [ 0 0 1000 0 ]
alter @vdrv_permit_req[pwl] = [ 0 1 1000 1 ]
alter @vset_mains_req[pwl] = [ 0 0 1000 0 ]
alter @vdrv_mains_req[pwl] = [ 0 1 1000 1 ]
alter @vset_vrelay_en[pwl] = [ 0 0 1000 0 ]
alter @vdrv_vrelay_en[pwl] = [ 0 1 1000 1 ]
echo CASO standby
print @cc528[capacitance]
tran 20u 2 0 20u uic
meas tran vrelay_j1_max MAX v(vrelay) FROM=1.5 TO=2
meas tran vreg_avg AVG v(vrelay_reg) FROM=1.6 TO=2
let p_t2 = v(t2_sec_a_e,t2_sec_b)*i(vt2_sns)
meas tran p_t2_avg AVG p_t2 FROM=1.6 TO=2
let p_t1 = v(t1_sec_aa_e)*i(vt1a_sns) + v(t1_sec_ab_e)*i(vt1b_sns)
meas tran p_t1_avg AVG p_t1 FROM=1.6 TO=2
destroy all
.endc
.end
