L62b d2Q125ccQ122cc L45a tr F2 g0 R126_cc musica=0 mute=0 - guasto a 0.3 s
.include @REPO@/models/jfet/lsk489.lib
.include @REPO@/models/bjt_npn/mmbt5551.lib
.include @REPO@/models/bjt_pnp/mmbt5401.lib
.include @REPO@/models/bjt_npn/mje15032.lib
.include @REPO@/models/bjt_pnp/mje15033.lib
.include @REPO@/models/diodes/1n4148.lib
.include @REPO@/models/bjt_pnp/ls350.lib
.include @REPO@/docs/preamp/data/2026-10-22/L45d2b3b2a/varianti/d2Q125ccQ122cc/gain_block.subckt
.include @REPO@/docs/preamp/data/2026-10-22/L45d2b3b2a/inc/d2Q125ccQ122cc/R126_cc.subckt
* interruttori: SWFC corto del guasto (chiuso con CTL=1), SWFO aperto del guasto (chiuso con
* CTL=0); SWKO / SWKC i due contatti del deviatore del mute (0,1 ohm, ADR-044): MUTE=0 rilasciato
.model SWFC SW(VT=0.5 VH=0.1 RON=0.01 ROFF=1e12)
.model SWFO SW(VT=-0.5 VH=0.1 RON=0.01 ROFF=1e12)
.model SWKO SW(VT=-0.5 VH=0.1 RON=0.1 ROFF=1e12)
.model SWKC SW(VT=0.5 VH=0.1 RON=0.1 ROFF=1e12)
VPP VPLUS 0 DC 15
VMM VMINUS 0 DC -15
VCTL CTL 0 PWL(0 0 0.3 0 0.30001 1)
VMUTE MUTE 0 DC 0
VIN SRC 0 DC 0
RSRC SRC JIN 1.5
CIN JIN SEL 1u
RJ JIN 0 10MEG
RSEL SEL 0 470k
RSELK SEL INA 0.1
XA INA OUTA FBA RGA RG10A VPLUS VMINUS GAINBLOCK
RRGA RGA 0 1G
CRGA RGA 0 15p
RRG10A RG10A 0 1G
CRG10A RG10A 0 15p
XF1 OUTA OUTF1 FBF1 RGF1 RG10F1 VPLUS VMINUS GAINBLOCK
RRGF1 RGF1 0 1G
CRGF1 RGF1 0 15p
RRG10F1 RG10F1 0 1G
CRG10F1 RG10F1 0 15p
XF2 OUTA OUTF2 FBF2 RGF2 RG10F2 VPLUS VMINUS CTL GAINBLOCKG
RRGF2 RGF2 0 1G
CRGF2 RGF2 0 15p
RRG10F2 RG10F2 0 1G
CRG10F2 RG10F2 0 15p
* scala del trim (845 + 464 + 464, sempre montata), trim a 0 dB, C_T, volume al massimo
RTR1 OUTA TAP6 845
RTR2 TAP6 TAP12 464
RTR3 TAP12 0 464
CT OUTA ATT 10u
RVT ATT W 1m
RVB W 0 10k
XB W OUTB FBB RGB RG10B VPLUS VMINUS GAINBLOCK
RRGB RGB 0 1G
CRGB RGB 0 15p
RRG10B RG10B 0 1G
CRG10B RG10B 0 15p
RSMAIN OUTB MAIN_A 47
CMAIN MAIN_A MAINC 4.7u
RBCMAIN MAINC 0 220k
SNOMAIN MAINC MAINJACK 0 MUTE SWKO
SNCMAIN MAINC 0 MUTE 0 SWKC
RBLMAIN MAINJACK 0 220k
RLDMAIN MAINJACK 0 100k
RSFIX1 OUTF1 FIX1_A 47
CFIX1 FIX1_A FIX1C 4.7u
RBCFIX1 FIX1C 0 470k
SNOFIX1 FIX1C FIX1JACK 0 MUTE SWKO
SNCFIX1 FIX1C 0 MUTE 0 SWKC
RBLFIX1 FIX1JACK 0 470k
RLDFIX1 FIX1JACK 0 10k
RSFIX2 OUTF2 FIX2_A 47
CFIX2 FIX2_A FIX2C 4.7u
RBCFIX2 FIX2C 0 470k
SNOFIX2 FIX2C FIX2JACK 0 MUTE SWKO
SNCFIX2 FIX2C 0 MUTE 0 SWKC
RBLFIX2 FIX2JACK 0 470k
RLDFIX2 FIX2JACK 0 50k
.control
set noaskquit
option itl1=1000
save v(mainjack) v(fix1jack) v(fix2jack) v(outa) v(outf1) v(outf2) v(outb) i(vpp) i(vmm) @q.xf2.q106[p] @q.xf2.q117[p] @q.xf2.q118[p] @q.xf2.q121a[p] @q.xf2.q121b[p] @q.xf2.q122[p] @q.xf2.q125[p] @q.xf2.q127[p] @q.xf2.q132[p] @q.xf2.q133[p] @q.xf2.q146[p] @q.xf2.q148[p] @r.xf2.r101[p] @r.xf2.r107[p] @r.xf2.r108[p] @r.xf2.r109[p] @r.xf2.r111[p] @r.xf2.r112[p] @r.xf2.r113[p] @r.xf2.r114[p] @r.xf2.r115[p] @r.xf2.r119[p] @r.xf2.r120[p] @r.xf2.r123[p] @r.xf2.r126[p] @r.xf2.r128[p] @r.xf2.r129[p] @r.xf2.r130[p] @r.xf2.r131[p] @r.xf2.r134[p] @r.xf2.r135[p] @r.xf2.r136[p] @r.xf2.r138[p] @r.xf2.r143[p] @r.xf2.r144[p] @r.xf2.r147[p] @r.xf2.r149[p] @r.xf2.r150[p] @r.xf2.r151[p] @r.xf2.r152[p] @r.xf2.r153[p] @r.xf2.r160[p] @j.xf2.jq110a[id] @j.xf2.jq110b[id] v(xf2.d1n) v(xf2.s1) v(xf2.d2n) v(xf2.s2) @d.xf2.d102[p] @d.xf2.d103[p] @d.xf2.d154[p] @d.xf2.d155[p] @d.xf2.d156[p] @d.xf2.d157[p] @d.xf2.d158[p] @d.xf2.d159[p]
tran 1u 2.3 0 50u
wrdata R126_cc.dat v(mainjack) v(fix1jack) v(fix2jack) v(outa) v(outf1) v(outf2) v(outb) i(vpp) i(vmm)
meas tran p_q106 AVG @q.xf2.q106[p] from=2.29 to=2.3
meas tran p_q117 AVG @q.xf2.q117[p] from=2.29 to=2.3
meas tran p_q118 AVG @q.xf2.q118[p] from=2.29 to=2.3
meas tran p_q121a AVG @q.xf2.q121a[p] from=2.29 to=2.3
meas tran p_q121b AVG @q.xf2.q121b[p] from=2.29 to=2.3
meas tran p_q122 AVG @q.xf2.q122[p] from=2.29 to=2.3
meas tran p_q125 AVG @q.xf2.q125[p] from=2.29 to=2.3
meas tran p_q127 AVG @q.xf2.q127[p] from=2.29 to=2.3
meas tran p_q132 AVG @q.xf2.q132[p] from=2.29 to=2.3
meas tran p_q133 AVG @q.xf2.q133[p] from=2.29 to=2.3
meas tran p_q146 AVG @q.xf2.q146[p] from=2.29 to=2.3
meas tran p_q148 AVG @q.xf2.q148[p] from=2.29 to=2.3
meas tran p_r101 AVG @r.xf2.r101[p] from=2.29 to=2.3
meas tran p_r107 AVG @r.xf2.r107[p] from=2.29 to=2.3
meas tran p_r108 AVG @r.xf2.r108[p] from=2.29 to=2.3
meas tran p_r109 AVG @r.xf2.r109[p] from=2.29 to=2.3
meas tran p_r111 AVG @r.xf2.r111[p] from=2.29 to=2.3
meas tran p_r112 AVG @r.xf2.r112[p] from=2.29 to=2.3
meas tran p_r113 AVG @r.xf2.r113[p] from=2.29 to=2.3
meas tran p_r114 AVG @r.xf2.r114[p] from=2.29 to=2.3
meas tran p_r115 AVG @r.xf2.r115[p] from=2.29 to=2.3
meas tran p_r119 AVG @r.xf2.r119[p] from=2.29 to=2.3
meas tran p_r120 AVG @r.xf2.r120[p] from=2.29 to=2.3
meas tran p_r123 AVG @r.xf2.r123[p] from=2.29 to=2.3
meas tran p_r126 AVG @r.xf2.r126[p] from=2.29 to=2.3
meas tran p_r128 AVG @r.xf2.r128[p] from=2.29 to=2.3
meas tran p_r129 AVG @r.xf2.r129[p] from=2.29 to=2.3
meas tran p_r130 AVG @r.xf2.r130[p] from=2.29 to=2.3
meas tran p_r131 AVG @r.xf2.r131[p] from=2.29 to=2.3
meas tran p_r134 AVG @r.xf2.r134[p] from=2.29 to=2.3
meas tran p_r135 AVG @r.xf2.r135[p] from=2.29 to=2.3
meas tran p_r136 AVG @r.xf2.r136[p] from=2.29 to=2.3
meas tran p_r138 AVG @r.xf2.r138[p] from=2.29 to=2.3
meas tran p_r143 AVG @r.xf2.r143[p] from=2.29 to=2.3
meas tran p_r144 AVG @r.xf2.r144[p] from=2.29 to=2.3
meas tran p_r147 AVG @r.xf2.r147[p] from=2.29 to=2.3
meas tran p_r149 AVG @r.xf2.r149[p] from=2.29 to=2.3
meas tran p_r150 AVG @r.xf2.r150[p] from=2.29 to=2.3
meas tran p_r151 AVG @r.xf2.r151[p] from=2.29 to=2.3
meas tran p_r152 AVG @r.xf2.r152[p] from=2.29 to=2.3
meas tran p_r153 AVG @r.xf2.r153[p] from=2.29 to=2.3
meas tran p_r160 AVG @r.xf2.r160[p] from=2.29 to=2.3
let pja = @j.xf2.jq110a[id] * (v(xf2.d1n) - v(xf2.s1))
let pjb = @j.xf2.jq110b[id] * (v(xf2.d2n) - v(xf2.s2))
meas tran p_jq110a AVG pja from=2.29 to=2.3
meas tran p_jq110b AVG pjb from=2.29 to=2.3
meas tran out_avg AVG v(outf2) from=2.29 to=2.3
meas tran out_max MAX v(outf2) from=2.29 to=2.3
meas tran out_min MIN v(outf2) from=2.29 to=2.3
meas tran ipp_avg AVG i(vpp) from=2.29 to=2.3
meas tran ipp_max MAX i(vpp) from=2.29 to=2.3
meas tran ipp_min MIN i(vpp) from=2.29 to=2.3
meas tran imm_avg AVG i(vmm) from=2.29 to=2.3
meas tran imm_max MAX i(vmm) from=2.29 to=2.3
meas tran imm_min MIN i(vmm) from=2.29 to=2.3
echo "grandezza,valore" > R126_cc_fine.csv
echo "p_q106,$&p_q106" >> R126_cc_fine.csv
echo "p_q117,$&p_q117" >> R126_cc_fine.csv
echo "p_q118,$&p_q118" >> R126_cc_fine.csv
echo "p_q121a,$&p_q121a" >> R126_cc_fine.csv
echo "p_q121b,$&p_q121b" >> R126_cc_fine.csv
echo "p_q122,$&p_q122" >> R126_cc_fine.csv
echo "p_q125,$&p_q125" >> R126_cc_fine.csv
echo "p_q127,$&p_q127" >> R126_cc_fine.csv
echo "p_q132,$&p_q132" >> R126_cc_fine.csv
echo "p_q133,$&p_q133" >> R126_cc_fine.csv
echo "p_q146,$&p_q146" >> R126_cc_fine.csv
echo "p_q148,$&p_q148" >> R126_cc_fine.csv
echo "p_r101,$&p_r101" >> R126_cc_fine.csv
echo "p_r107,$&p_r107" >> R126_cc_fine.csv
echo "p_r108,$&p_r108" >> R126_cc_fine.csv
echo "p_r109,$&p_r109" >> R126_cc_fine.csv
echo "p_r111,$&p_r111" >> R126_cc_fine.csv
echo "p_r112,$&p_r112" >> R126_cc_fine.csv
echo "p_r113,$&p_r113" >> R126_cc_fine.csv
echo "p_r114,$&p_r114" >> R126_cc_fine.csv
echo "p_r115,$&p_r115" >> R126_cc_fine.csv
echo "p_r119,$&p_r119" >> R126_cc_fine.csv
echo "p_r120,$&p_r120" >> R126_cc_fine.csv
echo "p_r123,$&p_r123" >> R126_cc_fine.csv
echo "p_r126,$&p_r126" >> R126_cc_fine.csv
echo "p_r128,$&p_r128" >> R126_cc_fine.csv
echo "p_r129,$&p_r129" >> R126_cc_fine.csv
echo "p_r130,$&p_r130" >> R126_cc_fine.csv
echo "p_r131,$&p_r131" >> R126_cc_fine.csv
echo "p_r134,$&p_r134" >> R126_cc_fine.csv
echo "p_r135,$&p_r135" >> R126_cc_fine.csv
echo "p_r136,$&p_r136" >> R126_cc_fine.csv
echo "p_r138,$&p_r138" >> R126_cc_fine.csv
echo "p_r143,$&p_r143" >> R126_cc_fine.csv
echo "p_r144,$&p_r144" >> R126_cc_fine.csv
echo "p_r147,$&p_r147" >> R126_cc_fine.csv
echo "p_r149,$&p_r149" >> R126_cc_fine.csv
echo "p_r150,$&p_r150" >> R126_cc_fine.csv
echo "p_r151,$&p_r151" >> R126_cc_fine.csv
echo "p_r152,$&p_r152" >> R126_cc_fine.csv
echo "p_r153,$&p_r153" >> R126_cc_fine.csv
echo "p_r160,$&p_r160" >> R126_cc_fine.csv
echo "p_jq110a,$&p_jq110a" >> R126_cc_fine.csv
echo "p_jq110b,$&p_jq110b" >> R126_cc_fine.csv
echo "out_avg,$&out_avg" >> R126_cc_fine.csv
echo "out_max,$&out_max" >> R126_cc_fine.csv
echo "out_min,$&out_min" >> R126_cc_fine.csv
echo "ipp_avg,$&ipp_avg" >> R126_cc_fine.csv
echo "ipp_max,$&ipp_max" >> R126_cc_fine.csv
echo "ipp_min,$&ipp_min" >> R126_cc_fine.csv
echo "imm_avg,$&imm_avg" >> R126_cc_fine.csv
echo "imm_max,$&imm_max" >> R126_cc_fine.csv
echo "imm_min,$&imm_min" >> R126_cc_fine.csv
meas tran p_d102 AVG @d.xf2.d102[p] from=2.29 to=2.3
echo "p_d102,$&p_d102" >> R126_cc_fine.csv
meas tran p_d103 AVG @d.xf2.d103[p] from=2.29 to=2.3
echo "p_d103,$&p_d103" >> R126_cc_fine.csv
meas tran p_d154 AVG @d.xf2.d154[p] from=2.29 to=2.3
echo "p_d154,$&p_d154" >> R126_cc_fine.csv
meas tran p_d155 AVG @d.xf2.d155[p] from=2.29 to=2.3
echo "p_d155,$&p_d155" >> R126_cc_fine.csv
meas tran p_d156 AVG @d.xf2.d156[p] from=2.29 to=2.3
echo "p_d156,$&p_d156" >> R126_cc_fine.csv
meas tran p_d157 AVG @d.xf2.d157[p] from=2.29 to=2.3
echo "p_d157,$&p_d157" >> R126_cc_fine.csv
meas tran p_d158 AVG @d.xf2.d158[p] from=2.29 to=2.3
echo "p_d158,$&p_d158" >> R126_cc_fine.csv
meas tran p_d159 AVG @d.xf2.d159[p] from=2.29 to=2.3
echo "p_d159,$&p_d159" >> R126_cc_fine.csv
quit
.endc
.end
