sfumatura L47b2b1 v5_carico_3_3_A
* GENERATO da docs/preamp/data/2026-10-03/L47b2b1/banco/sfumatura.py. Banco ridotto di L47b1.
.include /Users/roberto/EDA/.claude/worktrees/L47b2b1/docs/preamp/data/2026-10-02/L47b1/banco/inc/jfet_angoli.lib
.include /Users/roberto/EDA/.claude/worktrees/L47b2b1/models/optocoupler/nsl32sr3_comportamentale.lib
.options reltol=1e-6 vntol=1e-6 abstol=1e-12
VSRC VSN 0 DC 0 AC 1 SIN(0 3.818 1k)
RSRC VSN SRCX 1.5
* R_IN del blocco A (gain_block.py, r_in=1M)
RIN AIN 0 1MEG
* ---- la cella a fotoresistenze NSL-32SR3: serie curva A, derivazione curva A ----
XLS ALS 0 SRCX AIN NSL32SR3_A
XLP ALP 0 AIN 0 NSL32SR3_A
* 10 M dall'anodo a massa: un LED col solo generatore non ha percorso in continua (L29b)
RALS ALS 0 10MEG
RALP ALP 0 10MEG
* il profilo: log10(I) contro d, interpolato linearmente (come BILS del banco V2);
* una tabella per verso, scelta dal tempo (il comando di rilascio a t = 4.3 s)
BILS 0 ALS I = time < 4.3 ? pow(10, pwl(V(DEP), 0,-2.1549, 0.025,-2.3984, 0.05,-2.6420, 0.075,-2.8855, 0.1,-3.1291, 0.125,-3.3726, 0.15,-3.6162, 0.175,-3.8597, 0.2,-4.1033, 0.225,-4.3468, 0.25,-4.5904, 0.275,-4.8339, 0.3,-5.0775, 0.325,-5.3210, 0.35,-5.5645, 0.375,-5.8081, 0.4,-6.0516, 0.425,-6.2952, 0.45,-6.5387, 0.475,-6.7823, 0.5,-7.0258, 0.525,-7.2694, 0.55,-7.5129, 0.575,-7.7565, 0.6,-8.0000, 0.625,-8.0000, 0.65,-8.0000, 0.675,-8.0000, 0.7,-8.0000, 0.725,-8.0000, 0.75,-8.0000, 0.775,-8.0000, 0.8,-8.0000, 0.825,-8.0000, 0.85,-8.0000, 0.875,-8.0000, 0.9,-8.0000, 0.925,-8.0000, 0.95,-8.0000, 0.975,-8.0000, 1,-8.0000)) : pow(10, pwl(V(DEP), 0,-2.1549, 0.025,-2.3984, 0.05,-2.6420, 0.075,-2.8855, 0.1,-3.1291, 0.125,-3.3726, 0.15,-3.6162, 0.175,-3.8597, 0.2,-4.1033, 0.225,-4.3468, 0.25,-4.5904, 0.275,-4.8339, 0.3,-5.0775, 0.325,-5.3210, 0.35,-5.5645, 0.375,-5.8081, 0.4,-6.0516, 0.425,-6.2952, 0.45,-6.5387, 0.475,-6.7823, 0.5,-7.0258, 0.525,-7.2694, 0.55,-7.5129, 0.575,-7.7565, 0.6,-8.0000, 0.625,-8.0000, 0.65,-8.0000, 0.675,-8.0000, 0.7,-8.0000, 0.725,-8.0000, 0.75,-8.0000, 0.775,-8.0000, 0.8,-8.0000, 0.825,-8.0000, 0.85,-8.0000, 0.875,-8.0000, 0.9,-8.0000, 0.925,-8.0000, 0.95,-8.0000, 0.975,-8.0000, 1,-8.0000))
BILP 0 ALP I = time < 4.3 ? pow(10, pwl(V(DEP), 0,-8.0000, 0.025,-8.0000, 0.05,-8.0000, 0.075,-8.0000, 0.1,-8.0000, 0.125,-8.0000, 0.15,-8.0000, 0.175,-8.0000, 0.2,-8.0000, 0.225,-8.0000, 0.25,-8.0000, 0.275,-8.0000, 0.2999,-8.0000, 0.3,-5.5229, 0.325,-5.4026, 0.35,-5.2823, 0.375,-5.1620, 0.4,-5.0417, 0.425,-4.9215, 0.45,-4.8012, 0.475,-4.6809, 0.5,-4.5606, 0.525,-4.4403, 0.55,-4.3200, 0.575,-4.1997, 0.6,-4.0795, 0.625,-3.9592, 0.65,-3.8389, 0.675,-3.7186, 0.7,-3.5983, 0.725,-3.4780, 0.75,-3.3578, 0.775,-3.2375, 0.8,-3.1172, 0.825,-2.9969, 0.85,-2.8766, 0.875,-2.7563, 0.9,-2.6360, 0.925,-2.5158, 0.95,-2.3955, 0.975,-2.2752, 1,-2.1549)) : pow(10, pwl(V(DEP), 0,-8.0000, 0.025,-8.0000, 0.05,-8.0000, 0.075,-8.0000, 0.1,-8.0000, 0.125,-8.0000, 0.15,-8.0000, 0.175,-8.0000, 0.2,-8.0000, 0.225,-8.0000, 0.25,-8.0000, 0.275,-8.0000, 0.3,-8.0000, 0.325,-8.0000, 0.35,-8.0000, 0.375,-8.0000, 0.3999,-8.0000, 0.4,-6.0000, 0.425,-5.9551, 0.45,-5.8814, 0.475,-5.7908, 0.5,-5.6870, 0.525,-5.5723, 0.55,-5.4479, 0.575,-5.3149, 0.6,-5.1741, 0.625,-5.0260, 0.65,-4.8712, 0.675,-4.7101, 0.7,-4.5430, 0.725,-4.3702, 0.75,-4.1920, 0.775,-4.0087, 0.8,-3.8204, 0.825,-3.6273, 0.85,-3.4296, 0.875,-3.2275, 0.9,-3.0211, 0.925,-2.8105, 0.95,-2.5959, 0.975,-2.3773, 1,-2.1549))
BDEP DEP 0 V = time < 4.3 ? min(max((time - 0.3)/3, 0), 1) : min(max(1 - (time - 4.3)/3, 0), 1)
.control
option itl1=1000
set numdgt=15
tran 10u 7.8 0 10u
wrdata v5_carico_3_3_A.dat v(ain) v(xls.xs) v(xlp.xs)
.endc
.end
