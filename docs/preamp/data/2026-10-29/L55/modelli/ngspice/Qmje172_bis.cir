* L55 op Qmje172
.include /Users/roberto/EDA/.claude/worktrees/L55/docs/preamp/data/2026-10-29/L55/modelli/scartati/mje172.lib
Q1 c b 0 Qmje172
Vc c 0 DC -15.0
Ib b 0 DC 0.000128092520816
.control
set temp = 25
op
print @q1[ic] @q1[ib] @q1[cpi] @q1[cmu] @q1[gm] @q1[vbe]
.endc
.end
