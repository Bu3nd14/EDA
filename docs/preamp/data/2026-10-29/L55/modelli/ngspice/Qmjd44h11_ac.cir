* L55 fT Qmjd44h11
.include /Users/roberto/EDA/.claude/worktrees/L55/docs/preamp/data/2026-10-29/L55/modelli/scartati/mjd44h11.lib
Q1 c b 0 Qmjd44h11
Vc c 0 DC 15.0
Ib 0 b DC 6.10495513467e-05 AC 1
.control
set temp = 25
ac dec 50 100k 5g
let hfe = mag(i(Vc))
wrdata /Users/roberto/EDA/.claude/worktrees/L55/docs/preamp/data/2026-10-29/L55/modelli/ngspice/Qmjd44h11_ac.csv hfe
.endc
.end
