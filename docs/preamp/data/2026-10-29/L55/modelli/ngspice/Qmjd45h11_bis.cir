* L55 op Qmjd45h11
.include /Users/roberto/EDA/.claude/worktrees/L55/docs/preamp/data/2026-10-29/L55/modelli/scartati/mjd45h11.lib
Q1 c b 0 Qmjd45h11
Vc c 0 DC -15.0
Ib b 0 DC 7.40995239065e-05
.control
set temp = 25
op
print @q1[ic] @q1[ib] @q1[cpi] @q1[cmu] @q1[gm] @q1[vbe]
.endc
.end
