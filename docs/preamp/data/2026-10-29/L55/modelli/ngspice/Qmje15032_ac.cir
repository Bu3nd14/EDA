* L55 fT Qmje15032
.include /Users/roberto/EDA/.claude/worktrees/L55/vendor/bjt_npn/onsemi/MJE15032/mje15032.lib
Q1 c b 0 Qmje15032
Vc c 0 DC 15.0
Ib 0 b DC 0.000194050731792 AC 1
.control
set temp = 25
ac dec 50 100k 5g
let hfe = mag(i(Vc))
wrdata /Users/roberto/EDA/.claude/worktrees/L55/docs/preamp/data/2026-10-29/L55/modelli/ngspice/Qmje15032_ac.csv hfe
.endc
.end
