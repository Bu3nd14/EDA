* L55 fT ZXTP19060CG
.include /Users/roberto/EDA/.claude/worktrees/L55/docs/preamp/data/2026-10-29/L55/modelli/scartati/ZXTP19060CG.spice.txt
Q1 c b 0 ZXTP19060CG
Vc c 0 DC -15.0
Ib b 0 DC 4.59883613801e-05 AC 1
.control
set temp = 25
ac dec 50 100k 5g
let hfe = mag(i(Vc))
wrdata /Users/roberto/EDA/.claude/worktrees/L55/docs/preamp/data/2026-10-29/L55/modelli/ngspice/ZXTP19060CG_ac.csv hfe
.endc
.end
