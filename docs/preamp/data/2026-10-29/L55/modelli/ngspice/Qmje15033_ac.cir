* L55 fT Qmje15033
.include /Users/roberto/EDA/.claude/worktrees/L55/vendor/bjt_pnp/onsemi/MJE15033/mje15033.lib
Q1 c b 0 Qmje15033
Vc c 0 DC -15.0
Ib b 0 DC 8.45254162132e-05 AC 1
.control
set temp = 25
ac dec 50 100k 5g
let hfe = mag(i(Vc))
wrdata /Users/roberto/EDA/.claude/worktrees/L55/docs/preamp/data/2026-10-29/L55/modelli/ngspice/Qmje15033_ac.csv hfe
.endc
.end
