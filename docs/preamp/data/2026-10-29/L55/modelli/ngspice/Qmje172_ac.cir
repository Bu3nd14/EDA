* L55 fT Qmje172
.include /Users/roberto/EDA/.claude/worktrees/L55/docs/preamp/data/2026-10-29/L55/modelli/scartati/mje172.lib
Q1 c b 0 Qmje172
Vc c 0 DC -15.0
Ib b 0 DC 0.000128092520816 AC 1
.control
set temp = 25
ac dec 50 100k 5g
let hfe = mag(i(Vc))
wrdata /Users/roberto/EDA/.claude/worktrees/L55/docs/preamp/data/2026-10-29/L55/modelli/ngspice/Qmje172_ac.csv hfe
.endc
.end
