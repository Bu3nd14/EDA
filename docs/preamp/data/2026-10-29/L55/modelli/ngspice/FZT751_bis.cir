* L55 op FZT751
.include /Users/roberto/EDA/.claude/worktrees/L55/docs/preamp/data/2026-10-29/L55/modelli/scartati/FZT751.spice.txt
Q1 c b 0 FZT751
Vc c 0 DC -15.0
Ib b 0 DC 0.000100723745957
.control
set temp = 25
op
print @q1[ic] @q1[ib] @q1[cpi] @q1[cmu] @q1[gm] @q1[vbe]
.endc
.end
