* L55 fT ZXTN19060CG
.include /Users/roberto/EDA/.claude/worktrees/L55/docs/preamp/data/2026-10-29/L55/modelli/scartati/ZXTN19060CG.spice.txt
Q1 c b 0 ZXTN19060CG
Vc c 0 DC 15.0
Ib 0 b DC 5.29128532054e-05 AC 1
.control
set temp = 25
ac dec 50 100k 5g
let hfe = mag(i(Vc))
wrdata /Users/roberto/EDA/.claude/worktrees/L55/docs/preamp/data/2026-10-29/L55/modelli/ngspice/ZXTN19060CG_ac.csv hfe
.endc
.end
