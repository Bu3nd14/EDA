* L55 fT FZT751
.include /Users/roberto/EDA/.claude/worktrees/L55/docs/preamp/data/2026-10-29/L55/modelli/scartati/FZT751.spice.txt
Q1 c b 0 FZT751
Vc c 0 DC -15.0
Ib b 0 DC 0.000100723745957 AC 1
.control
set temp = 25
ac dec 50 100k 5g
let hfe = mag(i(Vc))
wrdata /Users/roberto/EDA/.claude/worktrees/L55/docs/preamp/data/2026-10-29/L55/modelli/ngspice/FZT751_ac.csv hfe
.endc
.end
