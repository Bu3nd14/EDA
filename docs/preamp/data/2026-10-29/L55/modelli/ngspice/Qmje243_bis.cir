* L55 op Qmje243
.include /Users/roberto/EDA/.claude/worktrees/L55/vendor/bjt_npn/onsemi/MJE243/mje243.lib
Q1 c b 0 Qmje243
Vc c 0 DC 15.0
Ib 0 b DC 5.30563157046e-05
.control
set temp = 25
op
print @q1[ic] @q1[ib] @q1[cpi] @q1[cmu] @q1[gm] @q1[vbe]
.endc
.end
