* L55 fT Qmje243
.include /Users/roberto/EDA/.claude/worktrees/L55/vendor/bjt_npn/onsemi/MJE243/mje243.lib
Q1 c b 0 Qmje243
Vc c 0 DC 15.0
Ib 0 b DC 5.30563157046e-05 AC 1
.control
set temp = 25
ac dec 50 100k 5g
let hfe = mag(i(Vc))
wrdata /Users/roberto/EDA/.claude/worktrees/L55/docs/preamp/data/2026-10-29/L55/modelli/ngspice/Qmje243_ac.csv hfe
.endc
.end
