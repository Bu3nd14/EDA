* L55 Cobo Qmje172
.include /Users/roberto/EDA/.claude/worktrees/L55/docs/preamp/data/2026-10-29/L55/modelli/scartati/mje172.lib
Q3 c3 0 e3 Qmje172
Re3 e3 0 1G
Vc3 c3 0 DC -10.0 AC 1
.control
set temp = 25
ac lin 1 100k 100k
let cre = real(i(Vc3))
let cim = imag(i(Vc3))
wrdata /Users/roberto/EDA/.claude/worktrees/L55/docs/preamp/data/2026-10-29/L55/modelli/ngspice/Qmje172_cobo.csv cre cim
.endc
.end
