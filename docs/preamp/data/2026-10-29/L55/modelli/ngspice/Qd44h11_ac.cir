* L55 fT Qd44h11
.include /Users/roberto/EDA/.claude/worktrees/L55/docs/preamp/data/2026-10-29/L55/modelli/scartati/d44h11.lib
Q1 c b 0 Qd44h11
Vc c 0 DC 15.0
Ib 0 b DC 0.000166211672101 AC 1
.control
set temp = 25
ac dec 50 100k 5g
let hfe = mag(i(Vc))
wrdata /Users/roberto/EDA/.claude/worktrees/L55/docs/preamp/data/2026-10-29/L55/modelli/ngspice/Qd44h11_ac.csv hfe
.endc
.end
