* L55 op FZT651
.include /Users/roberto/EDA/.claude/worktrees/L55/docs/preamp/data/2026-10-29/L55/modelli/scartati/FZT651.spice.txt
Q1 c b 0 FZT651
Vc c 0 DC 15.0
Ib 0 b DC 8.14218971211e-05
.control
set temp = 25
op
print @q1[ic] @q1[ib] @q1[cpi] @q1[cmu] @q1[gm] @q1[vbe]
.endc
.end
