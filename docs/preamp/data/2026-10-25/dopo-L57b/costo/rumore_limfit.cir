rumore - L57b: il costo della protezione dell'ingresso, prot=S,rif=eq,dio=fit
* generato da L57b/script/dist.py (il banco di L57a, la protezione dal subckt generato)
.include @REPO@/models/jfet/lsk489.lib
.include @REPO@/models/bjt_npn/mmbt5551.lib
.include @REPO@/models/bjt_pnp/mmbt5401.lib
.include @REPO@/models/bjt_npn/mje15032.lib
.include @REPO@/models/bjt_pnp/mje15033.lib
.include @REPO@/models/diodes/1n4148.lib
.include @REPO@/models/bjt_pnp/ls350.lib
.include @REPO@/spice/preamp/gain_block.subckt

VPP VPLUS 0 DC 15
VMM VMINUS 0 DC -15
VIN VSN 0 DC 0 AC 1
RSRC VSN JIN 2500
RJ    JIN 0 10Meg
CIN   JIN SEL 1u
RSEL  SEL 0 470k
RKSEL SEL NK 0.1
.include @REPO@/docs/preamp/data/2026-10-25/dopo-L57b/modelli/bav199_fit_come_di.lib
* la protezione dell'ingresso, dal subckt generato (L57b, limitatore.py: rif=eq dio=fit)
D179A VLIM_M AIN DI_BAV199
D179B AIN VLIM_P DI_BAV199
R179 NK AIN 1k
C1 VLIM_P 0 100n
C2 VLIM_M 0 100n
R4 VPLUS VLIM_P 10k
R5 VLIM_M VMINUS 10k
VU1 N_U1 0 DC 4.992
RZU1 VLIM_P N_U1 1.1
VU2 N_U2 VLIM_M DC 4.992
RZU2 0 N_U2 1.1
.nodeset v(VLIM_P)=4.992 v(VLIM_M)=-4.992
.include @REPO@/docs/preamp/data/2026-10-25/dopo-L57b/costo/nodeset.inc
CSEL  AIN 0 68p
XA AIN AOUT AFB ARG ARG10 VPLUS VMINUS GAINBLOCK
RARG   ARG   0 1G
RARG10 ARG10 0 1G
RL1 AOUT 0 1773
XF1 AOUT F1OUT F1FB F1RG F1RG10 VPLUS VMINUS GAINBLOCK
RF1RG   F1RG   0 1G
RF1RG10 F1RG10 0 1G
RSEP1 F1OUT FIX1 47
CFIX1 FIX1 FIXJACK1 4.7u
RBL1  FIXJACK1 0 470k
RLD1  FIXJACK1 0 10k
* rshunt 1 TOhm su ogni nodo: senza, alcuni punti di lavoro coi diodi ripiegavano su un blocco
* spento (vedi NODESET); su questi nodi pesa meno di una parte su un milione
.options reltol=1e-6 abstol=1e-15 vntol=1e-9 rshunt=1e12
.control
option itl1=1000
set numdgt=6
ac lin 1 1k 1k
let g = vm(aout)[0]
echo "L57A_GUADAGNO g=$&g"
noise v(aout) vin dec 100 20 20k
setplot noise2
let n_uv = onoise_total * 1e6
echo "L57A_RUMORE prot=S,rif=eq,dio=fit onoise_aout_uv=$&n_uv"
.endc
.end
