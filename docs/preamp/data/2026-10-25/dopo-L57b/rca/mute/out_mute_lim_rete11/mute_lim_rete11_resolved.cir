rca - L57b: l'RCA a caldo sul circuito di oggi (NC-059), prot=S,rif=eq rete=1.10
* generato da L57b/script/genera.py (il banco di L57a, la protezione dal subckt generato)
.include /Users/roberto/EDA/.claude/worktrees/dopo-L57b/models/jfet/lsk489.lib
.include /Users/roberto/EDA/.claude/worktrees/dopo-L57b/models/bjt_npn/mmbt5551.lib
.include /Users/roberto/EDA/.claude/worktrees/dopo-L57b/models/bjt_pnp/mmbt5401.lib
.include /Users/roberto/EDA/.claude/worktrees/dopo-L57b/models/bjt_npn/mje15032.lib
.include /Users/roberto/EDA/.claude/worktrees/dopo-L57b/models/bjt_pnp/mje15033.lib
.include /Users/roberto/EDA/.claude/worktrees/dopo-L57b/models/diodes/1n4148.lib
.include /Users/roberto/EDA/.claude/worktrees/dopo-L57b/models/bjt_pnp/ls350.lib
.include /Users/roberto/EDA/.claude/worktrees/dopo-L57b/spice/preamp/gain_block.subckt

VPP VPLUS 0 DC 15
VMM VMINUS 0 DC -15
.model swk sw vt=0.5 vh=0.1 ron=0.1 roff=1e9

* la sorgente e il suo cavo
VMAINS VMN 0 SIN(0 178.9 50)
CY  VMN SG 1n
RSG SG 0 1e12
VCG CG 0 PULSE(0 1 60m 1u 1u 1 2)
SWG SG 0 CG 0 swk
VOFF SG SOI DC 0.01
RS  SOI SO 1.5
VCT CT 0 PULSE(0 1 50m 1u 1u 1 2)
SWT SO JIN CT 0 swk
* il selettore (ADR-064)
RJ    JIN 0 10Meg
CIN   JIN SEL 1u
RSEL  SEL 0 470k
RKSEL SEL NK 0.1
.include /Users/roberto/EDA/.claude/worktrees/dopo-L57b/models/diodes/bav199.lib
* la protezione dell'ingresso, dal subckt generato (L57b, limitatore.py: rif=eq dio=di)
D179A VLIM_M AIN DI_BAV199
D179B AIN VLIM_P DI_BAV199
R179 NK AIN 1k
C1 VLIM_P 0 100n
C2 VLIM_M 0 100n
R4 VPLUS VLIM_P 10k
R5 VLIM_M VMINUS 10k
VU1 N_U1 0 DC 4.992
RZU1 VLIM_P N_U1 1.1
VU2 N_U2 VLIM_M DC 4.992
RZU2 0 N_U2 1.1
.nodeset v(VLIM_P)=4.992 v(VLIM_M)=-4.992
.save all @d179a[id] @d179b[id]
CSEL  AIN 0 68p
XA AIN AOUT AFB ARG ARG10 VPLUS VMINUS GAINBLOCK
RARG   ARG   0 1G
RARG10 ARG10 0 1G
* una fissa (ADR-023), col carico della Stax
XF1 AOUT F1OUT F1FB F1RG F1RG10 VPLUS VMINUS GAINBLOCK
RF1RG   F1RG   0 1G
RF1RG10 F1RG10 0 1G
RSEP1 F1OUT FIX1 47
CFIX1 FIX1 FIXC1 4.7u
RBC1  FIXC1 0 470k
CK2   FIXC1 FIXJACK1 1p
RBL1  FIXJACK1 0 470k
RLD1  FIXJACK1 0 50k
* trim 0 dB, C_T, bilanciamento al centro, volume (come L53/catena)
RT1R AOUT ATOP 0.1
RL1 AOUT 0 1773
CT    ATOP ATT 10u
CWIRE ATT 0 100p
RBAL  ATT 0 50k
RATTH ATT BIN 1m
RATTL BIN 0 10k
RGB   BIN 0 1MEG
XB BIN BOUT BFB BRG BRG10 VPLUS VMINUS GAINBLOCK
CSTB    BRG   0 15p
RRGB    BRG   0 1G
CSTB10  BRG10 0 15p
RRG10B  BRG10 0 1G
RISO   BOUT BOUTA 47
COUT   BOUTA MAINC 4.7u
CK4    MAINC MAIN 1p
RBLEED MAIN 0 220k
RLOAD  MAIN 0 100k
RBCM   MAINC 0 220k
.options reltol=1e-4 abstol=1e-12 vntol=1e-7

.control
option itl1=1000
set numdgt=6
echo "caso,vol,modo,rete,main_pk_v,main_pk_prima_massa_v,fix_pk_v,ain_pk_v,gg_max_v,gg_min_v,gs_max_v,gs_min_v,ig_max_ma,ig_min_ma,ig_dopo_ma,id_max_ma,vin_rail_v,gd_max_v,gd_min_v,veb117_max_v" > rca.csv
alter cy = 1n
alter voff = 0.01
alter rattH = 1m
alter rattL = 10k
alter rrgb = 1G
alter rrg10b = 1G
tran 10u 0.4 0 10u
let abs_main = abs(v(main))
let abs_fix = abs(v(fixjack1))
let abs_ain = abs(v(ain))
let gg = v(xa.g1) - v(xa.g2)
let gs = v(xa.g1) - v(xa.s1)
let ig = (v(ain) - v(xa.g1)) / 100 * 1000
let abs_ig = abs(ig)
meas tran mpk max abs_main from=50.0m to=0.4
meas tran mpre max abs_main from=50.0m to=60m
meas tran fpk max abs_fix from=50.0m to=0.4
meas tran apk max abs_ain from=50.0m to=0.4
meas tran ggmax max gg from=50m to=0.4
meas tran ggmin min gg from=50m to=0.4
meas tran gsmax max gs from=50m to=0.4
meas tran gsmin min gs from=50m to=0.4
meas tran igmax max ig from=50m to=0.4
meas tran igmin min ig from=50m to=0.4
meas tran igdopo max abs_ig from=50.2m to=0.4
let gd = v(xa.g1) - v(xa.d1n)
let veb = v(xa.d1n) - v(xa.ncasc)
meas tran gdmax max gd from=50m to=0.4
meas tran gdmin min gd from=50m to=0.4
meas tran vebmax max veb from=50m to=0.4
let id = max(abs(@d179a[id]), abs(@d179b[id])) * 1000
meas tran idmax max id from=50m to=0.4
let vr = max(v(ain) - v(vplus), v(vminus) - v(ain))
meas tran vrmax max vr from=50m to=0.4
meas tran vlpmax max v(vlim_p) from=50m to=0.4
meas tran vlmmin min v(vlim_m) from=50m to=0.4
let ir179 = abs(v(nk) - v(ain)) / 1000 * 1000
meas tran ir179max max ir179 from=50m to=0.4
echo "L57B_LIM vlp_max=$&vlpmax vlm_min=$&vlmmin ir179_max_ma=$&ir179max"
echo "L57A_RCA caso=classeII_1n vol=cima modo=0"
echo "classeII_1n,cima,0,1.1,$&mpk,$&mpre,$&fpk,$&apk,$&ggmax,$&ggmin,$&gsmax,$&gsmin,$&igmax,$&igmin,$&igdopo,$&idmax,$&vrmax,$&gdmax,$&gdmin,$&vebmax" >> rca.csv
destroy all
alter cy = 1n
alter voff = 0.01
alter rattH = 1m
alter rattL = 10k
alter rrgb = 0.1
alter rrg10b = 0.1
tran 10u 0.4 0 10u
let abs_main = abs(v(main))
let abs_fix = abs(v(fixjack1))
let abs_ain = abs(v(ain))
let gg = v(xa.g1) - v(xa.g2)
let gs = v(xa.g1) - v(xa.s1)
let ig = (v(ain) - v(xa.g1)) / 100 * 1000
let abs_ig = abs(ig)
meas tran mpk max abs_main from=50.0m to=0.4
meas tran mpre max abs_main from=50.0m to=60m
meas tran fpk max abs_fix from=50.0m to=0.4
meas tran apk max abs_ain from=50.0m to=0.4
meas tran ggmax max gg from=50m to=0.4
meas tran ggmin min gg from=50m to=0.4
meas tran gsmax max gs from=50m to=0.4
meas tran gsmin min gs from=50m to=0.4
meas tran igmax max ig from=50m to=0.4
meas tran igmin min ig from=50m to=0.4
meas tran igdopo max abs_ig from=50.2m to=0.4
let gd = v(xa.g1) - v(xa.d1n)
let veb = v(xa.d1n) - v(xa.ncasc)
meas tran gdmax max gd from=50m to=0.4
meas tran gdmin min gd from=50m to=0.4
meas tran vebmax max veb from=50m to=0.4
let id = max(abs(@d179a[id]), abs(@d179b[id])) * 1000
meas tran idmax max id from=50m to=0.4
let vr = max(v(ain) - v(vplus), v(vminus) - v(ain))
meas tran vrmax max vr from=50m to=0.4
meas tran vlpmax max v(vlim_p) from=50m to=0.4
meas tran vlmmin min v(vlim_m) from=50m to=0.4
let ir179 = abs(v(nk) - v(ain)) / 1000 * 1000
meas tran ir179max max ir179 from=50m to=0.4
echo "L57B_LIM vlp_max=$&vlpmax vlm_min=$&vlmmin ir179_max_ma=$&ir179max"
echo "L57A_RCA caso=classeII_1n vol=cima modo=10"
echo "classeII_1n,cima,10,1.1,$&mpk,$&mpre,$&fpk,$&apk,$&ggmax,$&ggmin,$&gsmax,$&gsmin,$&igmax,$&igmin,$&igdopo,$&idmax,$&vrmax,$&gdmax,$&gdmin,$&vebmax" >> rca.csv
destroy all
alter cy = 1n
alter voff = 0.01
alter rattH = 9645
alter rattL = 355
alter rrgb = 1G
alter rrg10b = 1G
tran 10u 0.4 0 10u
let abs_main = abs(v(main))
let abs_fix = abs(v(fixjack1))
let abs_ain = abs(v(ain))
let gg = v(xa.g1) - v(xa.g2)
let gs = v(xa.g1) - v(xa.s1)
let ig = (v(ain) - v(xa.g1)) / 100 * 1000
let abs_ig = abs(ig)
meas tran mpk max abs_main from=50.0m to=0.4
meas tran mpre max abs_main from=50.0m to=60m
meas tran fpk max abs_fix from=50.0m to=0.4
meas tran apk max abs_ain from=50.0m to=0.4
meas tran ggmax max gg from=50m to=0.4
meas tran ggmin min gg from=50m to=0.4
meas tran gsmax max gs from=50m to=0.4
meas tran gsmin min gs from=50m to=0.4
meas tran igmax max ig from=50m to=0.4
meas tran igmin min ig from=50m to=0.4
meas tran igdopo max abs_ig from=50.2m to=0.4
let gd = v(xa.g1) - v(xa.d1n)
let veb = v(xa.d1n) - v(xa.ncasc)
meas tran gdmax max gd from=50m to=0.4
meas tran gdmin min gd from=50m to=0.4
meas tran vebmax max veb from=50m to=0.4
let id = max(abs(@d179a[id]), abs(@d179b[id])) * 1000
meas tran idmax max id from=50m to=0.4
let vr = max(v(ain) - v(vplus), v(vminus) - v(ain))
meas tran vrmax max vr from=50m to=0.4
meas tran vlpmax max v(vlim_p) from=50m to=0.4
meas tran vlmmin min v(vlim_m) from=50m to=0.4
let ir179 = abs(v(nk) - v(ain)) / 1000 * 1000
meas tran ir179max max ir179 from=50m to=0.4
echo "L57B_LIM vlp_max=$&vlpmax vlm_min=$&vlmmin ir179_max_ma=$&ir179max"
echo "L57A_RCA caso=classeII_1n vol=k11 modo=0"
echo "classeII_1n,k11,0,1.1,$&mpk,$&mpre,$&fpk,$&apk,$&ggmax,$&ggmin,$&gsmax,$&gsmin,$&igmax,$&igmin,$&igdopo,$&idmax,$&vrmax,$&gdmax,$&gdmin,$&vebmax" >> rca.csv
destroy all
alter cy = 1n
alter voff = 0.01
alter rattH = 9645
alter rattL = 355
alter rrgb = 0.1
alter rrg10b = 0.1
tran 10u 0.4 0 10u
let abs_main = abs(v(main))
let abs_fix = abs(v(fixjack1))
let abs_ain = abs(v(ain))
let gg = v(xa.g1) - v(xa.g2)
let gs = v(xa.g1) - v(xa.s1)
let ig = (v(ain) - v(xa.g1)) / 100 * 1000
let abs_ig = abs(ig)
meas tran mpk max abs_main from=50.0m to=0.4
meas tran mpre max abs_main from=50.0m to=60m
meas tran fpk max abs_fix from=50.0m to=0.4
meas tran apk max abs_ain from=50.0m to=0.4
meas tran ggmax max gg from=50m to=0.4
meas tran ggmin min gg from=50m to=0.4
meas tran gsmax max gs from=50m to=0.4
meas tran gsmin min gs from=50m to=0.4
meas tran igmax max ig from=50m to=0.4
meas tran igmin min ig from=50m to=0.4
meas tran igdopo max abs_ig from=50.2m to=0.4
let gd = v(xa.g1) - v(xa.d1n)
let veb = v(xa.d1n) - v(xa.ncasc)
meas tran gdmax max gd from=50m to=0.4
meas tran gdmin min gd from=50m to=0.4
meas tran vebmax max veb from=50m to=0.4
let id = max(abs(@d179a[id]), abs(@d179b[id])) * 1000
meas tran idmax max id from=50m to=0.4
let vr = max(v(ain) - v(vplus), v(vminus) - v(ain))
meas tran vrmax max vr from=50m to=0.4
meas tran vlpmax max v(vlim_p) from=50m to=0.4
meas tran vlmmin min v(vlim_m) from=50m to=0.4
let ir179 = abs(v(nk) - v(ain)) / 1000 * 1000
meas tran ir179max max ir179 from=50m to=0.4
echo "L57B_LIM vlp_max=$&vlpmax vlm_min=$&vlmmin ir179_max_ma=$&ir179max"
echo "L57A_RCA caso=classeII_1n vol=k11 modo=10"
echo "classeII_1n,k11,10,1.1,$&mpk,$&mpre,$&fpk,$&apk,$&ggmax,$&ggmin,$&gsmax,$&gsmin,$&igmax,$&igmin,$&igdopo,$&idmax,$&vrmax,$&gdmax,$&gdmin,$&vebmax" >> rca.csv
destroy all
alter cy = 3.46n
alter voff = 0.01
alter rattH = 1m
alter rattL = 10k
alter rrgb = 1G
alter rrg10b = 1G
tran 10u 0.4 0 10u
let abs_main = abs(v(main))
let abs_fix = abs(v(fixjack1))
let abs_ain = abs(v(ain))
let gg = v(xa.g1) - v(xa.g2)
let gs = v(xa.g1) - v(xa.s1)
let ig = (v(ain) - v(xa.g1)) / 100 * 1000
let abs_ig = abs(ig)
meas tran mpk max abs_main from=50.0m to=0.4
meas tran mpre max abs_main from=50.0m to=60m
meas tran fpk max abs_fix from=50.0m to=0.4
meas tran apk max abs_ain from=50.0m to=0.4
meas tran ggmax max gg from=50m to=0.4
meas tran ggmin min gg from=50m to=0.4
meas tran gsmax max gs from=50m to=0.4
meas tran gsmin min gs from=50m to=0.4
meas tran igmax max ig from=50m to=0.4
meas tran igmin min ig from=50m to=0.4
meas tran igdopo max abs_ig from=50.2m to=0.4
let gd = v(xa.g1) - v(xa.d1n)
let veb = v(xa.d1n) - v(xa.ncasc)
meas tran gdmax max gd from=50m to=0.4
meas tran gdmin min gd from=50m to=0.4
meas tran vebmax max veb from=50m to=0.4
let id = max(abs(@d179a[id]), abs(@d179b[id])) * 1000
meas tran idmax max id from=50m to=0.4
let vr = max(v(ain) - v(vplus), v(vminus) - v(ain))
meas tran vrmax max vr from=50m to=0.4
meas tran vlpmax max v(vlim_p) from=50m to=0.4
meas tran vlmmin min v(vlim_m) from=50m to=0.4
let ir179 = abs(v(nk) - v(ain)) / 1000 * 1000
meas tran ir179max max ir179 from=50m to=0.4
echo "L57B_LIM vlp_max=$&vlpmax vlm_min=$&vlmmin ir179_max_ma=$&ir179max"
echo "L57A_RCA caso=classeII_3n46 vol=cima modo=0"
echo "classeII_3n46,cima,0,1.1,$&mpk,$&mpre,$&fpk,$&apk,$&ggmax,$&ggmin,$&gsmax,$&gsmin,$&igmax,$&igmin,$&igdopo,$&idmax,$&vrmax,$&gdmax,$&gdmin,$&vebmax" >> rca.csv
destroy all
alter cy = 3.46n
alter voff = 0.01
alter rattH = 1m
alter rattL = 10k
alter rrgb = 0.1
alter rrg10b = 0.1
tran 10u 0.4 0 10u
let abs_main = abs(v(main))
let abs_fix = abs(v(fixjack1))
let abs_ain = abs(v(ain))
let gg = v(xa.g1) - v(xa.g2)
let gs = v(xa.g1) - v(xa.s1)
let ig = (v(ain) - v(xa.g1)) / 100 * 1000
let abs_ig = abs(ig)
meas tran mpk max abs_main from=50.0m to=0.4
meas tran mpre max abs_main from=50.0m to=60m
meas tran fpk max abs_fix from=50.0m to=0.4
meas tran apk max abs_ain from=50.0m to=0.4
meas tran ggmax max gg from=50m to=0.4
meas tran ggmin min gg from=50m to=0.4
meas tran gsmax max gs from=50m to=0.4
meas tran gsmin min gs from=50m to=0.4
meas tran igmax max ig from=50m to=0.4
meas tran igmin min ig from=50m to=0.4
meas tran igdopo max abs_ig from=50.2m to=0.4
let gd = v(xa.g1) - v(xa.d1n)
let veb = v(xa.d1n) - v(xa.ncasc)
meas tran gdmax max gd from=50m to=0.4
meas tran gdmin min gd from=50m to=0.4
meas tran vebmax max veb from=50m to=0.4
let id = max(abs(@d179a[id]), abs(@d179b[id])) * 1000
meas tran idmax max id from=50m to=0.4
let vr = max(v(ain) - v(vplus), v(vminus) - v(ain))
meas tran vrmax max vr from=50m to=0.4
meas tran vlpmax max v(vlim_p) from=50m to=0.4
meas tran vlmmin min v(vlim_m) from=50m to=0.4
let ir179 = abs(v(nk) - v(ain)) / 1000 * 1000
meas tran ir179max max ir179 from=50m to=0.4
echo "L57B_LIM vlp_max=$&vlpmax vlm_min=$&vlmmin ir179_max_ma=$&ir179max"
echo "L57A_RCA caso=classeII_3n46 vol=cima modo=10"
echo "classeII_3n46,cima,10,1.1,$&mpk,$&mpre,$&fpk,$&apk,$&ggmax,$&ggmin,$&gsmax,$&gsmin,$&igmax,$&igmin,$&igdopo,$&idmax,$&vrmax,$&gdmax,$&gdmin,$&vebmax" >> rca.csv
destroy all
alter cy = 3.46n
alter voff = 0.01
alter rattH = 9645
alter rattL = 355
alter rrgb = 1G
alter rrg10b = 1G
tran 10u 0.4 0 10u
let abs_main = abs(v(main))
let abs_fix = abs(v(fixjack1))
let abs_ain = abs(v(ain))
let gg = v(xa.g1) - v(xa.g2)
let gs = v(xa.g1) - v(xa.s1)
let ig = (v(ain) - v(xa.g1)) / 100 * 1000
let abs_ig = abs(ig)
meas tran mpk max abs_main from=50.0m to=0.4
meas tran mpre max abs_main from=50.0m to=60m
meas tran fpk max abs_fix from=50.0m to=0.4
meas tran apk max abs_ain from=50.0m to=0.4
meas tran ggmax max gg from=50m to=0.4
meas tran ggmin min gg from=50m to=0.4
meas tran gsmax max gs from=50m to=0.4
meas tran gsmin min gs from=50m to=0.4
meas tran igmax max ig from=50m to=0.4
meas tran igmin min ig from=50m to=0.4
meas tran igdopo max abs_ig from=50.2m to=0.4
let gd = v(xa.g1) - v(xa.d1n)
let veb = v(xa.d1n) - v(xa.ncasc)
meas tran gdmax max gd from=50m to=0.4
meas tran gdmin min gd from=50m to=0.4
meas tran vebmax max veb from=50m to=0.4
let id = max(abs(@d179a[id]), abs(@d179b[id])) * 1000
meas tran idmax max id from=50m to=0.4
let vr = max(v(ain) - v(vplus), v(vminus) - v(ain))
meas tran vrmax max vr from=50m to=0.4
meas tran vlpmax max v(vlim_p) from=50m to=0.4
meas tran vlmmin min v(vlim_m) from=50m to=0.4
let ir179 = abs(v(nk) - v(ain)) / 1000 * 1000
meas tran ir179max max ir179 from=50m to=0.4
echo "L57B_LIM vlp_max=$&vlpmax vlm_min=$&vlmmin ir179_max_ma=$&ir179max"
echo "L57A_RCA caso=classeII_3n46 vol=k11 modo=0"
echo "classeII_3n46,k11,0,1.1,$&mpk,$&mpre,$&fpk,$&apk,$&ggmax,$&ggmin,$&gsmax,$&gsmin,$&igmax,$&igmin,$&igdopo,$&idmax,$&vrmax,$&gdmax,$&gdmin,$&vebmax" >> rca.csv
destroy all
alter cy = 3.46n
alter voff = 0.01
alter rattH = 9645
alter rattL = 355
alter rrgb = 0.1
alter rrg10b = 0.1
tran 10u 0.4 0 10u
let abs_main = abs(v(main))
let abs_fix = abs(v(fixjack1))
let abs_ain = abs(v(ain))
let gg = v(xa.g1) - v(xa.g2)
let gs = v(xa.g1) - v(xa.s1)
let ig = (v(ain) - v(xa.g1)) / 100 * 1000
let abs_ig = abs(ig)
meas tran mpk max abs_main from=50.0m to=0.4
meas tran mpre max abs_main from=50.0m to=60m
meas tran fpk max abs_fix from=50.0m to=0.4
meas tran apk max abs_ain from=50.0m to=0.4
meas tran ggmax max gg from=50m to=0.4
meas tran ggmin min gg from=50m to=0.4
meas tran gsmax max gs from=50m to=0.4
meas tran gsmin min gs from=50m to=0.4
meas tran igmax max ig from=50m to=0.4
meas tran igmin min ig from=50m to=0.4
meas tran igdopo max abs_ig from=50.2m to=0.4
let gd = v(xa.g1) - v(xa.d1n)
let veb = v(xa.d1n) - v(xa.ncasc)
meas tran gdmax max gd from=50m to=0.4
meas tran gdmin min gd from=50m to=0.4
meas tran vebmax max veb from=50m to=0.4
let id = max(abs(@d179a[id]), abs(@d179b[id])) * 1000
meas tran idmax max id from=50m to=0.4
let vr = max(v(ain) - v(vplus), v(vminus) - v(ain))
meas tran vrmax max vr from=50m to=0.4
meas tran vlpmax max v(vlim_p) from=50m to=0.4
meas tran vlmmin min v(vlim_m) from=50m to=0.4
let ir179 = abs(v(nk) - v(ain)) / 1000 * 1000
meas tran ir179max max ir179 from=50m to=0.4
echo "L57B_LIM vlp_max=$&vlpmax vlm_min=$&vlmmin ir179_max_ma=$&ir179max"
echo "L57A_RCA caso=classeII_3n46 vol=k11 modo=10"
echo "classeII_3n46,k11,10,1.1,$&mpk,$&mpre,$&fpk,$&apk,$&ggmax,$&ggmin,$&gsmax,$&gsmin,$&igmax,$&igmin,$&igdopo,$&idmax,$&vrmax,$&gdmax,$&gdmin,$&vebmax" >> rca.csv
destroy all
.endc
.end
