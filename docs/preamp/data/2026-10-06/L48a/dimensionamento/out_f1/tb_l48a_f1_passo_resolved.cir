tb_l48a_f1_passo.cir - L48a: il gradino al cambio d'ingresso fra due sorgenti a continue diverse, con e senza la rete per ingresso (dimensionamento di RSEL)
* Prima riga = titolo (docs/limitations.md #10).
*
* COSA SI PROVA (L48a, NC-040, F1, PR-14). Due sorgenti, A selezionata e B
* no. Per ciascuna: VDC --RS-- J --CIN (con la perdita RLK)-- SEL --RSEL a massa;
* SEL --contatto del selettore-- AIN. Al tempo TS il contatto di A si apre e,
* dopo il trasferimento, si chiude quello di B. Si misura il picco dello
* scostamento rispetto a prima del cambio:
*   AIN    l'ingresso del blocco A
*   JF     il jack di un'uscita fissa (buffer, 47, 4,7u, 470k + 50k di carico)
*   JM     il jack principale (trim 0 dB, attenuatore al massimo, blocco B a
*          +10 dB, 47, 4,7u, 220k + 100k): il caso peggiore del principale
* Limite di F1: 100 uV di picco su ogni uscita (33 dB SPL).
*
* Il controfattuale (caso 0) e' l'ingresso di oggi: niente CIN (RBYP 1 mohm),
* niente RSEL. Deve dare sui jack circa la differenza delle continue.
*
* RLK = 1e4 / CIN: costante d'isolamento 10 000 s, il minimo del poliestere
* citato in L43a (WIMA MKS 4); e' un limite per eccesso per il polipropilene.
*
* Il contatto: switch ron 0,1 ohm, roff 1 GOhm, 15 pF in parallelo (tb_trim).
* Trasferimento 1 ms (B si chiude 1 ms dopo che A si apre); il caso "sovrap"
* chiude B 1 ms PRIMA che A si apra (due rele' monostabili, uno che rilascia
* e uno che attira: l'ordine non e' garantito).
*
* Tabella (echo): f1_passo.csv
*   caso,rsel,vb,rsb,trasf,ain_su_uv,ain_giu_uv,jf_su_uv,jf_giu_uv,jm_su_uv,jm_giu_uv

.include /Users/roberto/EDA/.claude/worktrees/L48a-selettore/models/jfet/lsk489.lib
.include /Users/roberto/EDA/.claude/worktrees/L48a-selettore/models/bjt_npn/mmbt5551.lib
.include /Users/roberto/EDA/.claude/worktrees/L48a-selettore/models/bjt_pnp/mmbt5401.lib
.include /Users/roberto/EDA/.claude/worktrees/L48a-selettore/models/bjt_npn/mje15032.lib
.include /Users/roberto/EDA/.claude/worktrees/L48a-selettore/models/bjt_pnp/mje15033.lib
.include /Users/roberto/EDA/.claude/worktrees/L48a-selettore/models/diodes/1n4148.lib
.include /Users/roberto/EDA/.claude/worktrees/L48a-selettore/models/bjt_pnp/ls350.lib
.include /Users/roberto/EDA/.claude/worktrees/L48a-selettore/spice/preamp/gain_block.subckt

VPP VPLUS 0 DC 15
VMM VMINUS 0 DC -15

.model swk sw vt=0.5 vh=0.1 ron=0.1 roff=1e9

* --- sorgente A (selezionata all'inizio), 0 V ---
VA   VAN 0 DC 0
RSA  VAN JA 1.5
CINA JA SELA 1u
RLKA JA SELA 1e10
RBYA JA SELA 1e15
RSLA SELA 0 470k
SWA  SELA AIN CTLA 0 swk
CKA  SELA AIN 15p

* --- sorgente B, a continua VB ---
VB   VBN 0 DC 0.01
RSB  VBN JB 1.5
CINB JB SELB 1u
RLKB JB SELB 1e10
RBYB JB SELB 1e15
RSLB SELB 0 470k
SWB  SELB AIN CTLB 0 swk
CKB  SELB AIN 15p

CSEL AIN 0 68p

* --- i comandi: A si apre a 50 ms; B si chiude a 51 ms (trasf) o a 49 ms (sovrap) ---
VCA  CTLA 0 PWL(0 1 50m 1 50.1m 0)
VCB1 CB1 0 PWL(0 0 51m 0 51.1m 1)
VCB2 CB2 0 PWL(0 0 49m 0 49.1m 1)
RCB1 CB1 CTLB 1m
RCB2 CB2 CTLB 1e12

* --- blocco A ---
XA AIN AOUT AFB ARG ARG10 VPLUS VMINUS GAINBLOCK
RARG   ARG   0 1G
RARG10 ARG10 0 1G

* --- un'uscita fissa: il buffer (ADR-023), 47, 4,7u, i due 470k, Stax 50k ---
XF AOUT FOUT FFB FRG FRG10 VPLUS VMINUS GAINBLOCK
RFRG   FRG   0 1G
RFRG10 FRG10 0 1G
RFISO  FOUT FOUTA 47
CFOUT  FOUTA JF 4.7u
RFBC   JF 0 470k
RFBL   JF 0 470k
RFLD   JF 0 50k

* --- il ramo principale: trim 0 dB, attenuatore al massimo, B a +10 dB ---
RL1 AOUT TAP6 845
RL2 TAP6 TAP12 464
RL3 TAP12 0 464
RT1R AOUT ATOP 0.1
CWIRE ATOP 0 100p
RATTH ATOP BIN 1m
RATTL BIN 0 10k
XB BIN BOUT BFB BRG BRG10 VPLUS VMINUS GAINBLOCK
CSTB    BRG   0 15p
RRGB    BRG   0 0.1
CSTB10  BRG10 0 15p
RRG10B  BRG10 0 0.1
RISO   BOUT BOUTA 47
COUT   BOUTA JM 4.7u
RBCM   JM 0 220k
RBLM   JM 0 220k
RLOAD  JM 0 100k

.options method=gear
.control
echo "caso,rsel,vb,rsb,trasf,ain_su_uv,ain_giu_uv,jf_su_uv,jf_giu_uv,jm_su_uv,jm_giu_uv" > f1_passo.csv
foreach caso 0 1 2 3 4 5 6 7 8 9 10 11
  * default: rete montata, RSEL 470k, B a 10 mV su 1,5 ohm, trasferimento
  alter rbya = 1e15
  alter rbyb = 1e15
  alter rsla = 470k
  alter rslb = 470k
  alter rsb = 1.5
  alter rcb1 = 1m
  alter rcb2 = 1e12
  set rs = r470k
  set tr = trasf
  if $caso = 0
    alter rbya = 1m
    alter rbyb = 1m
    alter rsla = 1e15
    alter rslb = 1e15
    alter @vb[dc] = 0.01
    set rs = oggi
  end
  if $caso = 1
    alter @vb[dc] = 0.01
  end
  if $caso = 2
    alter @vb[dc] = 0.1
  end
  if $caso = 3
    alter @vb[dc] = 1
  end
  if $caso = 4
    alter @vb[dc] = 0.01
    alter rsb = 1Meg
  end
  if $caso = 5
    alter @vb[dc] = 1
    alter rcb1 = 1e12
    alter rcb2 = 1m
    set tr = sovrap
  end
  if $caso = 6
    alter rsla = 1Meg
    alter rslb = 1Meg
    alter @vb[dc] = 0.01
    set rs = r1M
  end
  if $caso = 7
    alter rsla = 1Meg
    alter rslb = 1Meg
    alter @vb[dc] = 0.1
    set rs = r1M
  end
  if $caso = 8
    alter rsla = 1Meg
    alter rslb = 1Meg
    alter @vb[dc] = 1
    set rs = r1M
  end
  if $caso = 9
    alter rsla = 1Meg
    alter rslb = 1Meg
    alter @vb[dc] = 0.01
    alter rsb = 1Meg
    set rs = r1M
  end
  if $caso = 10
    alter @vb[dc] = 0
    set rs = r470k_zero
  end
  if $caso = 11
    alter @vb[dc] = 0.1
    alter rcb1 = 1e12
    alter rcb2 = 1m
    set tr = sovrap
  end
  tran 20u 350m 0 50u
  meas tran a0 find v(ain) at=48m
  meas tran f0 find v(jf) at=48m
  meas tran m0 find v(jm) at=48m
  meas tran amax max v(ain) from=48m to=350m
  meas tran amin min v(ain) from=48m to=350m
  meas tran fmax max v(jf) from=48m to=350m
  meas tran fmin min v(jf) from=48m to=350m
  meas tran mmax max v(jm) from=48m to=350m
  meas tran mmin min v(jm) from=48m to=350m
  let au = 1e6*(amax - a0)
  let ad = 1e6*(a0 - amin)
  let fu = 1e6*(fmax - f0)
  let fd = 1e6*(f0 - fmin)
  let mu = 1e6*(mmax - m0)
  let md = 1e6*(m0 - mmin)
  let vbv = v(vbn)[0]
  let rsbv = @rsb[resistance]
  echo "F1 caso=$caso"
  print au ad fu fd mu md
  echo "$caso,$rs,$&vbv,$&rsbv,$tr,$&au,$&ad,$&fu,$&fd,$&mu,$&md" >> f1_passo.csv
  destroy all
end
.endc

.end
