* L47c2a tb_psu seq perdita (giro 1) - GENERATED by genera_tb_psu.py from /Users/roberto/EDA/.claude/worktrees/L54b3b/circuits/preamp/psu.net and None - L54a --timer sorgente - L54b3a ritenuta=costruttore bat54=costruttore sonde-piu=True - L54b3b toll=toll_mc081.json
* toll {"fattori": {"C518": 1.0355211468580128, "C527": 1.0296884763323848, "C528": 0.961218079744382, "C529": 0.9732117728833731, "C548": 1.0191591682724201, "C549": 1.0417052163505816, "C550": 0.9946308364154726, "C551": 1.0092494134838963, "C552": 1.0224219470110343, "C553": 1.0488012833110822, "R504": 1.0040245173504865, "R505": 0.9981893522117185, "R506": 1.0004386417944813, "R507": 1.0050687162461127, "R508": 1.0084110192473772, "R509": 1.0079894929806472, "R512": 1.0069769473120027, "R522": 1.0074718936984426, "R523": 0.9963765645776926, "R534": 1.0083750362046697, "R536": 1.0000083484166793, "R555": 1.0046795481556243, "R569": 0.991642680951363, "R570": 0.9945977162029747, "R571": 0.9928709673328795, "R572": 1.0081234375286496, "R574": 0.9972960196545877, "R578": 0.9929113401289282, "R580": 0.9932571606708022, "R581": 1.0097888415277518, "R582": 0.9978703527930858, "R583": 1.0090113425410965, "R585": 1.007821958643772}, "ib": -1.389646754153763e-08, "nota": "L54b3b MC seme 54 campione 81 temp 25 x7r -", "vos": {"U505a": -0.0011453153481843232, "U505b": 0.002146266479877413, "U506a": -0.0005890247387077173, "U506b": -0.000802394226756864, "U508a": 0.0008457619916852669, "U508b": 0.0034930972524689773, "U513a": 0.0028579218459921555, "U513b": 0.0006619272101618781, "U513c": 0.0008650062688760442, "U513d": -0.001474076049364998, "U514a": 0.0005800401236387924, "U514b": -0.002553710041258014, "U514c": -0.0024276462874611173, "U514d": 0.0009029783753178844, "U515a": -0.0024344342064316275, "U515b": -5.097834740373253e-05, "U515c": 0.0015432229199379898, "U515d": 0.0011728874490818475}, "vref": 2.5000579167050776}
.include /Users/roberto/EDA/.claude/worktrees/L54b3b/models/diodes/bat54.lib
.include /Users/roberto/EDA/.claude/worktrees/L54b3b/models/bjt_npn/bc847b.lib
.include /Users/roberto/EDA/.claude/worktrees/L54b3b/models/bjt_pnp/bc857b.lib

.include /Users/roberto/EDA/.claude/worktrees/L54b3b/models/diodes/1n4148.lib
.include /Users/roberto/EDA/.claude/worktrees/L54b3b/models/diodes/bav199.lib
.include /Users/roberto/EDA/.claude/worktrees/L54b3b/models/mosfet_n/generic_nmos.lib
.include /Users/roberto/EDA/.claude/worktrees/L54b3b/models/mosfet_p/generic_pmos.lib
.include /Users/roberto/EDA/.claude/worktrees/L54b3b/models/bjt_npn/generic_npn.lib
.include /Users/roberto/EDA/.claude/worktrees/L54b3b/models/bjt_pnp/generic_pnp.lib
* declared generic models (L41a): bridge diode, Schottky, 24 V zener; L41b1: BAT54
.model DBR D(Is=1e-9 N=1.8 Rs=0.03)
.model DSCH D(Is=1e-6 N=1.1 Rs=0.05)
.model DZ24 D(Is=1e-12 N=1 Rs=1 BV=24 IBV=1m)
.model DBAT54 D(Is=2e-8 N=1.05 Rs=1)

* behavioural positive / negative regulator: gm to VSET, clamped to [0, ILIM],
* dropout VDO, no reverse current, input current = output current + IQ
.subckt REGP in out gnd en VSET=15 VDO=0.3 ILIM=1 IQ=1m
Bo gnd out I = V(en)*min({ILIM}, max(0, 1000*(min({VSET}, V(in,gnd)-{VDO}) - V(out,gnd))))
Bi in gnd I = V(en)*min({ILIM}, max(0, 1000*(min({VSET}, V(in,gnd)-{VDO}) - V(out,gnd)))) + {IQ}*(V(in,gnd)>1)
Rl out gnd 1meg
.ends
.subckt REGM in out gnd en VSET=15 VDO=0.3 ILIM=1 IQ=1m
Bo out gnd I = V(en)*min({ILIM}, max(0, 1000*(min({VSET}, V(gnd,in)-{VDO}) - V(gnd,out))))
Bi gnd in I = V(en)*min({ILIM}, max(0, 1000*(min({VSET}, V(gnd,in)-{VDO}) - V(gnd,out)))) + {IQ}*(V(gnd,in)>1)
Rl out gnd 1meg
.ends
* L45d2b2a (NC-063): the same two regulators WITH their soft-start. A reference node r (1 F) is
* charged while EN is high and IN is above the UVLO, and discharged in 1 ms otherwise (ASSUMED:
* the datasheets do not say how fast NR is discharged); the output regulates to min(VSET, V(r)).
*  - TPS7A4701 (SBVS204G, UVLO 2.67 V rising): r charges by RC, time constant TAU = 100 kOhm x C_NR,
*    towards VSET + 5 V, so that it reaches VSET at TAU ln((VSET + 5) / 5) - eq. 5, the only figure
*    the datasheet gives (a typical device; the shape before it is ASSUMED);
*  - TPS7A3301 (SBVS169D, UVLO -2 V): r rises linearly to VSET in TSS = 1.2 ms per nF - eq. 1 (the
*    linear ramp is ASSUMED, as fig. 29 draws it).
.subckt REGPSS in out gnd en VSET=15 VDO=0.3 ILIM=1 IQ=1m TAU=1
* (a 0 V sense on IN: i(v.x<ref>.vsns) is the current the regulator draws, positive)
Vsns in ins 0
Bon on 0 V = V(en)*0.5*(1+tanh((V(ins,gnd)-2.67)/0.05))
Cr r 0 1
Br 0 r I = V(on)*({VSET}+5-V(r))/{TAU} - (1-V(on))*V(r)/1m
Bo gnd out I = V(en)*min({ILIM}, max(0, 1000*(min(min({VSET}, V(r)), V(ins,gnd)-{VDO}) - V(out,gnd))))
Bi ins gnd I = V(en)*min({ILIM}, max(0, 1000*(min(min({VSET}, V(r)), V(ins,gnd)-{VDO}) - V(out,gnd)))) + {IQ}*(V(ins,gnd)>1)
Rl out gnd 1meg
.ends
.subckt REGMSS in out gnd en VSET=15 VDO=0.3 ILIM=1 IQ=1m TSS=1
Vsns ins in 0
Bon on 0 V = V(en)*0.5*(1+tanh((V(gnd,ins)-2)/0.05))
Cr r 0 1
Br 0 r I = V(on)*{VSET}/{TSS}*0.5*(1-tanh((V(r)-{VSET}-0.5)/0.05)) - (1-V(on))*V(r)/1m
Bo out gnd I = V(en)*min({ILIM}, max(0, 1000*(min(min({VSET}, V(r)), V(gnd,ins)-{VDO}) - V(gnd,out))))
Bi gnd ins I = V(en)*min({ILIM}, max(0, 1000*(min(min({VSET}, V(r)), V(gnd,ins)-{VDO}) - V(gnd,out)))) + {IQ}*(V(gnd,ins)>1)
Rl out gnd 1meg
.ends
* behavioural open-drain comparator: output sinks when inn > inp, 1 us,
* high impedance with its supply below 2 V; 55 uA from its supply (L41b1)
.subckt CMPOD inp inn out vcc gnd
Bu u gnd V = 0.5*(1+tanh((V(inn)-V(inp))/1m)) * 0.5*(1+tanh((V(vcc,gnd)-2)/0.1))
Ru u uf 1k
Cu uf gnd 1n
Bs out gnd I = V(out,gnd)/50 * V(uf,gnd)
Rleak out gnd 1G
Bq vcc gnd I = 55u*(V(vcc,gnd)>1)
.ends
* behavioural LM4040-2.5 shunt
.subckt SHUNT25 k a
Bz k a I = max(0, V(k,a)-2.5000579167050776)*20
.ends

.model DSB340 D(Is=8.7e-5 N=1.47 Rs=0.0136)
.include /Users/roberto/EDA/.claude/worktrees/L54b3b/docs/preamp/data/2026-10-28/L54b3b/psu/cmpta.lib
.include /Users/roberto/EDA/.claude/worktrees/L54b3b/docs/preamp/data/2026-10-28/L54b3b/psu/cmpta_v.lib
* L54b2 --comparatore tarato
CC501 raw_p c501_esr {0.8*4700u}
RC501_esr c501_esr 0 0.03
CC502 0 c502_esr {0.8*4700u}
RC502_esr c502_esr raw_m 0.03
CC505 vplus c505_esr {0.8*2200u}
RC505_esr c505_esr 0 0.03
CC506 0 c506_esr {0.8*2200u}
RC506_esr c506_esr vminus 0.03
CC507 nr_p 0 4.7u
CC508 0 nr_m 470n
CC509 raw_pr 0 10u
CC510 0 raw_mr 10u
CC511 vplus_reg 0 10u
CC512 0 vminus_reg 10u
CC513 vminus_reg fb_m 10n
CC514 vref rly_ret 100n
CC515 sup_p rly_ret 1n
CC516 sup_m rly_ret 1n
CC517 v5 rly_ret 100n
CC518 md rly_ret {100n*1.03552}
CC519 v5 rly_ret 100n
CC520 raw_v c520_esr {0.8*4700u}
RC520_esr c520_esr rly_ret 0.03
CC521 nr_v rly_ret 10u
CC522 raw_v rly_ret 10u
CC523 vrelay_reg c523_esr {0.8*2200u}
RC523_esr c523_esr rly_ret 0.03
CC524 vrelay_reg rly_ret 1u
CC525 v5 rly_ret 1u
CC526 sup_vr rly_ret 1n
CC527 mute_g rly_ret {22n*1.02969}
CC528 permit_t rly_ret {100n*0.961218}
CC529 vr_t rly_ret {100n*0.973212}
CC530 v5 rly_ret 100n
CC531 sw_g vrelay_reg 100n
CC532 front_in rly_ret 100n
CC533 mute_sw_in rly_ret 100n
CC536 v5_pre rly_ret 1u
CC545 v5 rly_ret 100n
CC546 v5 rly_ret 100n
CC547 v5 rly_ret 100n
CC548 at_pgt rly_ret {1u*1.01916}
CC549 at_mrq rly_ret {100n*1.04171}
CC550 at_prt rly_ret {10n*0.994631}
CC551 at_mt rly_ret {100n*1.00925}
CC552 at_t2s rly_ret {1u*1.02242}
CC553 at_f rly_ret {330n*1.0488}
CC554 at_bn rly_ret 1n
CC555 vrelay_en at_bp 1n
DD501a t1_sec_a raw_p DBR
DD501b t1_sec_b raw_p DBR
DD501c raw_m t1_sec_a DBR
DD501d raw_m t1_sec_b DBR
DD503a t2_sec_a rect_v DBR
DD503b t2_sec_b rect_v DBR
DD503c rly_ret t2_sec_a DBR
DD503d rly_ret t2_sec_b DBR
DD504 rect_v raw_v DSCH
DD505 mains_coil mains_coil_d D1N914
DD506 mute_cmd clamp_mute_d D1N914
DD507 vrelay clamp_mute DZ24
DD508 permit_cmd clamp_permit_d D1N914
DD509 vrelay clamp_permit DZ24
DD510 vplus_reg raw_pr DSB340
DD511 raw_mr vminus_reg DSB340
DD512 vrelay_reg raw_v DSCH
DD513 vplus_reg raw_pr DSB340
DD514 raw_mr vminus_reg DSB340
DD515 vplus_reg vplus DSB340
DD516 vminus vminus_reg DSB340
DD520 pt_a permit_t D1N914
DD521 pt_b permit_t D1N914
DD522 mute_g permit_g DBAT54
DD523 permit_t vr_t D1N914
DD524 ve_a vr_t D1N914
DD530 clamp_mute_d clamp_mute D1N914
DD531 clamp_permit_d clamp_permit D1N914
DD532 mains_coil_d vrelay_reg D1N914
DD533 at_pg at_md BAT54
DD534 at_f at_md BAT54
DD535 at_t2s at_md DI_BAV199
DD536 at_pgt at_pg DI_BAV199
DD537 at_mrq vrelay_en BAT54
DD538 at_mrq at_prt D1N914
DD539 at_ma at_mt D1N914
DD540 vr_g at_mt D1N914
DD541 at_t2s vrelay_en DI_BAV199
RF501 ac_l t2_pri_l 1m
RK501_coil vrelay_reg mains_coil 360
RNT501 rly_ret 0 1m
MQ501 mute_cmd mute_g rly_ret rly_ret MNGEN W=571u L=1u
MQ502 permit_cmd permit_g rly_ret rly_ret MNGEN W=571u L=1u
MQ503 mains_sink mains_g rly_ret rly_ret MNGEN W=571u L=1u
QQ504 md md_b rly_ret QNGEN
MQ505 vrelay sw_g vrelay_reg vrelay_reg MPGEN W=28000u L=1u
MQ506 sw_d vr_g rly_ret rly_ret MNGEN W=571u L=1u
QQ513 at_bp at_bn rly_ret DI_BC847B
QQ514 at_bn at_bp vrelay_en DI_BC857B
RR501 vminus_reg fb_m 120k
RR502 fb_m 0 10k
RR503 v5 vref_r 1k
RR504 vref vref_half {10k*1.00402}
RR505 vref_half rly_ret {10k*0.998189}
RR506 vplus sup_p {44.2k*1.00044}
RR507 sup_p rly_ret {10k*1.00507}
RR508 vref sup_m {10k*1.00841}
RR509 sup_m vminus {118k*1.00799}
RR510 rect_v md_b_r 11k
RR511 md_b rly_ret 4.7k
RR512 v5 md_r {110k*1.00698}
RR513 mute_req mute_g 10k
RR514 mute_g rly_ret 100k
RR516 permit_g rly_ret 100k
RR517 v5 mute_sw 100k
RR518 v5 front_sw 100k
RR520 mains_req mains_g 10k
RR521 mains_g rly_ret 100k
RR522 vrelay_reg sup_vr {34k*1.00747}
RR523 sup_vr rly_ret {10k*0.996377}
RR524 v5 permit_g 10k
RR525 mute_req rly_ret 100k
RR526 permit_req rly_ret 100k
RR527 vrelay_en rly_ret 100k
RR528 mains_req rly_ret 100k
RR532 mute_req pt_a 1k
RR533 permit_req pt_b 1k
RR534 permit_t rly_ret {332k*1.00838}
RR535 vrelay_en ve_a 1k
RR536 vr_t rly_ret {1MEG*1.00001}
RR537 v5 vr_g 10k
RR538 vr_g rly_ret 100k
RR539 sw_d sw_g 47k
RR540 sw_g vrelay_reg 100k
RR541 front_sw front_in 1k
RR542 mute_sw mute_sw_in 1k
RR550 raw_p raw_pr 4.7
RR551 raw_mr raw_m 4.7
RR552 mains_coil mains_sink 47
RR553 vref_r vref 1k
RR554 md_b_r md_b 11k
RR555 md_r md {110k*1.00468}
RR569 v5 at_md {100k*0.991643}
RR570 v5 at_pg {100k*0.994598}
RR571 v5 at_pgt {1MEG*0.992871}
RR572 v5 at_mrq {200k*1.00812}
RR573 v5 mute_req 10k
RR574 at_prt rly_ret {4.7MEG*0.997296}
RR575 v5 permit_req 10k
RR576 v5 vrelay_en 10k
RR577 vrelay_en at_ma 1k
RR578 at_mt rly_ret {1MEG*0.992911}
RR579 v5 mains_req 22k
RR580 vrelay_en at_t2s {2.7MEG*0.993257}
RR581 v5 at_f {100k*1.00979}
RR582 at_f at_bn {47k*0.99787}
RR583 at_bn rly_ret {100k*1.00901}
RR584 vrelay_en at_bp 100k
RR585 at_f rly_ret {33k*1.00782}
XU501 raw_pr vplus_reg 0 en_u501 REGPSS VSET=15.3 VDO=0.3 ILIM=1 IQ=0.58m TAU=0.47
VENU501 en_u501 0 pwl(0 1 1000 1)
XU502 raw_mr vminus_reg 0 en_u502 REGMSS VSET=15.288 VDO=0.3 ILIM=1 IQ=1m TSS=0.564
VENU502 en_u502 0 pwl(0 1 1000 1)
XU503 raw_v vrelay_reg rly_ret en_u503 REGPSS VSET=12 VDO=0.3 ILIM=1 IQ=0.58m TAU=1
VENU503 en_u503 0 pwl(0 1 1000 1)
XU504 vrelay_reg v5_pre rly_ret en_u504 REGP VSET=5 VDO=0.6 ILIM=0.25 IQ=2u
VENU504 en_u504 0 pwl(0 1 1000 1)
XU505a sup_p vref mute_g v5 rly_ret CMPTAV VOS=-0.00114532 IB=-1.38965e-08 VON=2
XU505b vref_half sup_m mute_g v5 rly_ret CMPTAV VOS=0.00214627 IB=-1.38965e-08 VON=2
XU506a vref md mute_g v5 rly_ret CMPTAV VOS=-0.000589025 IB=-1.38965e-08 VON=2
XU506b sup_vr vref mute_g v5 rly_ret CMPTAV VOS=-0.000802394 IB=-1.38965e-08 VON=2
XU507 vref rly_ret SHUNT25
XU508a permit_t vref permit_g v5 rly_ret CMPTAV VOS=0.000845762 IB=-1.38965e-08 VON=2
XU508b vr_t vref vr_g v5 rly_ret CMPTAV VOS=0.0034931 IB=-1.38965e-08 VON=2
XU512 v5_pre v5 rly_ret en_u512 REGP VSET=5 VDO=0.02 ILIM=0.25 IQ=2u
VENU512 en_u512 0 pwl(0 1 1000 1)
XU513a sup_p vref at_pg v5 rly_ret CMPTAV VOS=0.00285792 IB=-1.38965e-08 VON=2
XU513b vref_half sup_m at_pg v5 rly_ret CMPTAV VOS=0.000661927 IB=-1.38965e-08 VON=2
XU513c sup_vr vref at_pg v5 rly_ret CMPTAV VOS=0.000865006 IB=-1.38965e-08 VON=2
XU513d vref md at_md v5 rly_ret CMPTAV VOS=-0.00147408 IB=-1.38965e-08 VON=2
XU514a at_pgt vref at_mrq v5 rly_ret CMPTAV VOS=0.00058004 IB=-1.38965e-08 VON=2
XU514b vref mute_sw_in at_mrq v5 rly_ret CMPTAV VOS=-0.00255371 IB=-1.38965e-08 VON=2
XU514c at_mrq vref mute_req v5 rly_ret CMPTAV VOS=-0.00242765 IB=-1.38965e-08 VON=2
XU514d at_prt vref permit_req v5 rly_ret CMPTAV VOS=0.000902978 IB=-1.38965e-08 VON=2
XU515a vref front_in vrelay_en v5 rly_ret CMPTAV VOS=-0.00243443 IB=-1.38965e-08 VON=2
XU515b at_mt vref mains_req v5 rly_ret CMPTAV VOS=-5.09783e-05 IB=-1.38965e-08 VON=2
XU515c at_t2s vref at_f v5 rly_ret CMPTAV VOS=0.00154322 IB=-1.38965e-08 VON=2
XU515d vref at_pg at_f v5 rly_ret CMPTAV VOS=0.00117289 IB=-1.38965e-08 VON=2
* L45d2b2a soft-start: U501 C507 = 4.7e-06 F: tau 0.47 s, t_SS = tau ln((15.3 + 5) / 5) = 0.6586 s (eq. 5)
* L45d2b2a soft-start: U502 C508 = 4.7e-07 F: t_SS = 1.2 ms/nF = 0.564 s (eq. 1)
* L45d2b2a soft-start: U503 C521 = 1e-05 F: tau 1 s, t_SS = tau ln((12 + 5) / 5) = 1.224 s (eq. 5)
R_float_ac_l ac_l 0 1G
R_float_ac_n ac_n 0 1G
R_float_t1_pri_l t1_pri_l 0 1G
R_float_t1_pri_n t1_pri_n 0 1G
R_float_t2_pri_l t2_pri_l 0 1G
VENV env 0 pwl(0 1 3 1 3.0001 0 1000 0)
BK501 k501_in 0 V = 0.5*(1+tanh((V(vrelay_reg,mains_coil)-8.4)/0.2))
RK501 k501_in k501_f 5k
CK501 k501_f 0 1u
BENV1 env1 0 V = V(env)*0.5*(1+tanh((V(k501_f)-0.5)/0.02))
BT1_SEC_Aa T1_SEC_Aa_e 0 V = V(env1)*22.9103*sin(2*pi*50*time)
VT1a_sns T1_SEC_Aa_e T1_SEC_Aa_i 0
BT1_SEC_Ab 0 T1_SEC_Ab_e V = V(env1)*22.9103*sin(2*pi*50*time)
VT1b_sns T1_SEC_Ab_e T1_SEC_Ab_i 0
RT1_SEC_Aa T1_SEC_Aa_i T1_SEC_Aa_l 0.7200
LT1_SEC_Aa T1_SEC_Aa_l t1_sec_a 100u
RT1_SEC_Ab T1_SEC_Ab_i T1_SEC_Ab_l 0.7200
LT1_SEC_Ab T1_SEC_Ab_l t1_sec_b 100u
BT2_SEC_A T2_SEC_A_e t2_sec_b V = V(env)*20.3647*sin(2*pi*50*time)
VT2_sns T2_SEC_A_e T2_SEC_A_i 0
RT2_SEC_A T2_SEC_A_i T2_SEC_A_l 5.7600
LT2_SEC_A T2_SEC_A_l t2_sec_a 100u
RT2_SEC_A_float t2_sec_b 0 10meg
VIQ iq_mcu 0 pwl(0 0 1000 0)
RLOADP vplus 0 49.4441
RLOADM 0 vminus 48.1481
CAUDIOP vplus 0 800.8u
RCELLE vplus vpf_celle 1.25
CCELLE vpf_celle 0 8000u
CAUDIOM 0 vminus 800.8u
RMUTECOIL vrelay mute_cmd 401.167
RPERMITCOIL vrelay permit_cmd 1315
RRESTO vrelay rly_ret 233.01
BTRIM vrelay rly_ret I = 0.0364*max(0, V(vrelay,rly_ret))/12*0.5*(1+tanh((V(permit_cmd,rly_ret)-6)/0.5))
VGSW3 g_sw3 0 pwl(0 1 1000 1)
BSW3 mute_sw rly_ret I = V(mute_sw,rly_ret)*V(g_sw3)
VGFRONT g_front 0 pwl(0 1 1000 1)
BFRONT front_sw rly_ret I = V(front_sw,rly_ret)*V(g_front)
.options reltol=1e-4 abstol=1e-10 vntol=1e-6 temp=25 method=gear gmin=1e-10
.control
set numdgt=12
set wr_singlescale
set wr_vecnames
option numdgt=12
tran 100u 4 0 20u uic
meas tran bn_max0 max v(at_bn) from=0.05 to=3
meas tran bn_max max v(at_bn) from=3 to=4
meas tran on_min min v(vrelay_en) from=3 to=4
linearize
wrdata tb_psu_seq_perdita_g1_out.txt v(front_in) v(mute_sw_in) v(mute_cmd) v(permit_cmd) v(vrelay) v(vrelay_reg) v(vplus) v(vminus) v(k501_f) v(mute_g) v(permit_g) v(env) v(mute_req) v(permit_req) v(mains_req) v(vrelay_en) v(vr_g) v(mains_g) v(raw_p) v(raw_m) i(v.xu501.vsns) i(v.xu502.vsns) v(raw_pr) v(raw_mr) v(at_pg) v(at_pgt) v(at_mrq) v(at_mt) v(at_t2s) v(at_f) v(at_md) v(at_prt) v(permit_t) v(vr_t) v(at_bn) v(at_bp) v(v5) v(raw_v) v(rect_v)
.endc
.end
