op_p4 - L56: rm100, Tj del passo 3, aria 57, rame
* generato da L56/script/caldo.py
.include /Users/roberto/EDA/.claude/worktrees/L56/models/jfet/lsk489.lib
.include /Users/roberto/EDA/.claude/worktrees/L56/models/bjt_npn/mmbt5551.lib
.include /Users/roberto/EDA/.claude/worktrees/L56/models/bjt_pnp/mmbt5401.lib
.include /Users/roberto/EDA/.claude/worktrees/L56/models/bjt_npn/mje15032.lib
.include /Users/roberto/EDA/.claude/worktrees/L56/models/bjt_pnp/mje15033.lib
.include /Users/roberto/EDA/.claude/worktrees/L56/models/diodes/1n4148.lib
.include /Users/roberto/EDA/.claude/worktrees/L56/models/bjt_pnp/ls350.lib
.include /Users/roberto/EDA/.claude/worktrees/L56/docs/preamp/data/2026-10-12/L56/inc/rm100__t57_rame_p3.inc

VPP VPLUS 0 DC 15
VMM VMINUS 0 DC -15
VS VSN 0 DC 0
RSRC VSN IN 2500
CSTRAY RG 0 15p
CSTRAY10 RG10 0 15p
RRG RG 0 1G
RRG10 RG10 0 1G
RISO OUT OUTA 47
COUT OUTA JACK 4.7u
RBLEED JACK 0 220k
RLOAD JACK 0 10k
.temp 57
.options reltol=1e-6 abstol=1e-15 vntol=1e-9

.control
set temp = 57
op
echo "L56_OP4 ta=57"
print all
print @jq110a[id] @jq110b[id] @q106[ic] @q117[ic] @q118[ic] @q121a[ic] @q121b[ic] @q122[ic] @q125[ic] @q127[ic] @q132[ic] @q133[ic]
destroy all
.endc
.end
