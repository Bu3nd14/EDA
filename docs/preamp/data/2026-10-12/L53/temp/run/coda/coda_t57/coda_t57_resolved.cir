coda_t57 - L53: THD a 20 kHz contro R107 (la corrente di coda) a 57 gradi (NC-058)
* generato da L53/temp/coda.py
.include /Users/roberto/EDA/.claude/worktrees/L53/models/jfet/lsk489.lib
.include /Users/roberto/EDA/.claude/worktrees/L53/models/bjt_npn/mmbt5551.lib
.include /Users/roberto/EDA/.claude/worktrees/L53/models/bjt_pnp/mmbt5401.lib
.include /Users/roberto/EDA/.claude/worktrees/L53/models/bjt_npn/mje15032.lib
.include /Users/roberto/EDA/.claude/worktrees/L53/models/bjt_pnp/mje15033.lib
.include /Users/roberto/EDA/.claude/worktrees/L53/models/diodes/1n4148.lib
.include /Users/roberto/EDA/.claude/worktrees/L53/models/bjt_pnp/ls350.lib
.include /Users/roberto/EDA/.claude/worktrees/L53/spice/preamp/gain_block_flat.inc

VPP VPLUS 0 DC 15
VMM VMINUS 0 DC -15
VS VSN 0 SIN(0 0.282843 20000)
RSRC VSN IN 2500
CSTRAY RG 0 15p
CSTRAY10 RG10 0 15p
RRG RG 0 1G
RRG10 RG10 0 1G
RISO OUT OUTA 47
COUT OUTA JACK 4.7u
RBLEED JACK 0 220k
RLOAD JACK 0 10k
.temp 57
.options reltol=1e-6 abstol=1e-15 vntol=1e-9

.control
option itl1=1000
set numdgt=10
set fourgridsize=8192
set nfreqs=10
alter r107 = 123.3
op
echo "L53_CODA r107=123.3"
print @q106[ic] @jq110a[id] @jq110b[id] v(out)
destroy all
alter @vs[sin] = [ 0 0.282843 20000 ]
save out vsn
tran 2e-08 0.0021 0 2e-08
echo "L46A_CASO modo=0 livello=lo freq=20000 ampin=0.282843 rs=2500 r107=123.3"
fourier 20000 v(vsn) v(out)
destroy all
alter r107 = 123.3
op
echo "L53_CODA r107=123.3"
print @q106[ic] @jq110a[id] @jq110b[id] v(out)
destroy all
alter @vs[sin] = [ 0 2.82843 20000 ]
save out vsn
tran 2e-08 0.0021 0 2e-08
echo "L46A_CASO modo=0 livello=hi freq=20000 ampin=2.82843 rs=2500 r107=123.3"
fourier 20000 v(vsn) v(out)
destroy all
alter r107 = 130.2
op
echo "L53_CODA r107=130.2"
print @q106[ic] @jq110a[id] @jq110b[id] v(out)
destroy all
alter @vs[sin] = [ 0 0.282843 20000 ]
save out vsn
tran 2e-08 0.0021 0 2e-08
echo "L46A_CASO modo=0 livello=lo freq=20000 ampin=0.282843 rs=2500 r107=130.2"
fourier 20000 v(vsn) v(out)
destroy all
alter r107 = 130.2
op
echo "L53_CODA r107=130.2"
print @q106[ic] @jq110a[id] @jq110b[id] v(out)
destroy all
alter @vs[sin] = [ 0 2.82843 20000 ]
save out vsn
tran 2e-08 0.0021 0 2e-08
echo "L46A_CASO modo=0 livello=hi freq=20000 ampin=2.82843 rs=2500 r107=130.2"
fourier 20000 v(vsn) v(out)
destroy all
alter r107 = 133.6
op
echo "L53_CODA r107=133.6"
print @q106[ic] @jq110a[id] @jq110b[id] v(out)
destroy all
alter @vs[sin] = [ 0 0.282843 20000 ]
save out vsn
tran 2e-08 0.0021 0 2e-08
echo "L46A_CASO modo=0 livello=lo freq=20000 ampin=0.282843 rs=2500 r107=133.6"
fourier 20000 v(vsn) v(out)
destroy all
alter r107 = 133.6
op
echo "L53_CODA r107=133.6"
print @q106[ic] @jq110a[id] @jq110b[id] v(out)
destroy all
alter @vs[sin] = [ 0 2.82843 20000 ]
save out vsn
tran 2e-08 0.0021 0 2e-08
echo "L46A_CASO modo=0 livello=hi freq=20000 ampin=2.82843 rs=2500 r107=133.6"
fourier 20000 v(vsn) v(out)
destroy all
alter r107 = 137
op
echo "L53_CODA r107=137"
print @q106[ic] @jq110a[id] @jq110b[id] v(out)
destroy all
alter @vs[sin] = [ 0 0.282843 20000 ]
save out vsn
tran 2e-08 0.0021 0 2e-08
echo "L46A_CASO modo=0 livello=lo freq=20000 ampin=0.282843 rs=2500 r107=137"
fourier 20000 v(vsn) v(out)
destroy all
alter r107 = 137
op
echo "L53_CODA r107=137"
print @q106[ic] @jq110a[id] @jq110b[id] v(out)
destroy all
alter @vs[sin] = [ 0 2.82843 20000 ]
save out vsn
tran 2e-08 0.0021 0 2e-08
echo "L46A_CASO modo=0 livello=hi freq=20000 ampin=2.82843 rs=2500 r107=137"
fourier 20000 v(vsn) v(out)
destroy all
alter r107 = 140.5
op
echo "L53_CODA r107=140.5"
print @q106[ic] @jq110a[id] @jq110b[id] v(out)
destroy all
alter @vs[sin] = [ 0 0.282843 20000 ]
save out vsn
tran 2e-08 0.0021 0 2e-08
echo "L46A_CASO modo=0 livello=lo freq=20000 ampin=0.282843 rs=2500 r107=140.5"
fourier 20000 v(vsn) v(out)
destroy all
alter r107 = 140.5
op
echo "L53_CODA r107=140.5"
print @q106[ic] @jq110a[id] @jq110b[id] v(out)
destroy all
alter @vs[sin] = [ 0 2.82843 20000 ]
save out vsn
tran 2e-08 0.0021 0 2e-08
echo "L46A_CASO modo=0 livello=hi freq=20000 ampin=2.82843 rs=2500 r107=140.5"
fourier 20000 v(vsn) v(out)
destroy all
alter r107 = 144
op
echo "L53_CODA r107=144"
print @q106[ic] @jq110a[id] @jq110b[id] v(out)
destroy all
alter @vs[sin] = [ 0 0.282843 20000 ]
save out vsn
tran 2e-08 0.0021 0 2e-08
echo "L46A_CASO modo=0 livello=lo freq=20000 ampin=0.282843 rs=2500 r107=144"
fourier 20000 v(vsn) v(out)
destroy all
alter r107 = 144
op
echo "L53_CODA r107=144"
print @q106[ic] @jq110a[id] @jq110b[id] v(out)
destroy all
alter @vs[sin] = [ 0 2.82843 20000 ]
save out vsn
tran 2e-08 0.0021 0 2e-08
echo "L46A_CASO modo=0 livello=hi freq=20000 ampin=2.82843 rs=2500 r107=144"
fourier 20000 v(vsn) v(out)
destroy all
alter r107 = 150.7
op
echo "L53_CODA r107=150.7"
print @q106[ic] @jq110a[id] @jq110b[id] v(out)
destroy all
alter @vs[sin] = [ 0 0.282843 20000 ]
save out vsn
tran 2e-08 0.0021 0 2e-08
echo "L46A_CASO modo=0 livello=lo freq=20000 ampin=0.282843 rs=2500 r107=150.7"
fourier 20000 v(vsn) v(out)
destroy all
alter r107 = 150.7
op
echo "L53_CODA r107=150.7"
print @q106[ic] @jq110a[id] @jq110b[id] v(out)
destroy all
alter @vs[sin] = [ 0 2.82843 20000 ]
save out vsn
tran 2e-08 0.0021 0 2e-08
echo "L46A_CASO modo=0 livello=hi freq=20000 ampin=2.82843 rs=2500 r107=150.7"
fourier 20000 v(vsn) v(out)
destroy all
.endc
.end
