tb_l48b_scatti - L48b variante 4: il gradino al jack a uno scatto del volume o del trim
* GENERATO da docs/preamp/data/2026-10-07/L48b/scatti/genera_scatti.py - non modificare a mano.
* Prima riga = titolo (limitations #10).
.include /Users/roberto/EDA/.claude/worktrees/L48b/models/jfet/lsk489.lib
.include /Users/roberto/EDA/.claude/worktrees/L48b/models/bjt_npn/mmbt5551.lib
.include /Users/roberto/EDA/.claude/worktrees/L48b/models/bjt_pnp/mmbt5401.lib
.include /Users/roberto/EDA/.claude/worktrees/L48b/models/bjt_npn/mje15032.lib
.include /Users/roberto/EDA/.claude/worktrees/L48b/models/bjt_pnp/mje15033.lib
.include /Users/roberto/EDA/.claude/worktrees/L48b/models/diodes/1n4148.lib
.include /Users/roberto/EDA/.claude/worktrees/L48b/models/bjt_pnp/ls350.lib
.include /Users/roberto/EDA/.claude/worktrees/L48b/spice/preamp/gain_block.subckt
* il blocco B vero non ha R113 (r_in=None, preamp_audio.py): la copia senza, scritta da
* genera_scatti.py dal file generato (col cursore aperto, m0, R113 deciderebbe il gate)
.include /Users/roberto/EDA/.claude/worktrees/L48b/docs/preamp/data/2026-10-07/L48b/scatti/deck/gain_block_b_senza_r113.subckt

VPP VPLUS 0 DC 15
VMM VMINUS 0 DC -15

* --- la sorgente scelta e la rete d'ingresso di ADR-064 (tb_trim.cir) ---
VSRC  VSN 0 DC 0 AC 1
RSRC  VSN JIN 1.5
RJ    JIN 0 10Meg
CIN   JIN SEL 1u
RSEL  SEL 0 470k
RKSEL SEL SELK 0.1
* la continua del blocco A (limitations #44: IOSA da' a R113 la corrente di VOSA)
VOSA  SELK AIN DC 0
IOSA  AIN 0 DC 0

XA AIN AOUT AFB ARG ARG10 VPLUS VMINUS GAINBLOCK
RARG   ARG   0 1G
RARG10 ARG10 0 1G

* --- v2: il condensatore all'uscita del blocco A, prima del trim (RBYA = 1m: assente) ---
CA   AOUT AOC 1p
RBYA AOUT AOC 1m

* --- la scala del trim, cand 2 di trim.py ---
RL1 AOC TAP6 845
RL2 TAP6 TAP12 464
RL3 TAP12 0 464

.model SWK SW(RON=0.1 ROFF=1e12 VT=0.5 VH=0.25)
* --- i contatti del trim, che si muovono nel tempo; 15 pF ciascuno ---
ST1R AOC ATOP NT1R 0 SWK
CT1R AOC ATOP 15p
ST1S T2C ATOP NT1S 0 SWK
CT1S T2C ATOP 15p
ST2R TAP6 T2C NT2R 0 SWK
CT2R TAP6 T2C 15p
ST2S TAP12 T2C NT2S 0 SWK
CT2S TAP12 T2C 15p
VT1R NT1R 0 PWL(0 1 1 1)
VT1S NT1S 0 PWL(0 0 1 0)
VT2R NT2R 0 PWL(0 1 1 1)
VT2S NT2S 0 PWL(0 0 1 0)

* --- v3: il condensatore fra il trim e l'attenuatore (RBYT = 1m: assente) ---
CTX  ATOP ATT 1p
RBYT ATOP ATT 1m
* il cablaggio verso l'attenuatore a pannello
CWIRE ATT 0 100p
* v4: il bilanciamento MN 50k allo scatto centrale (ADR-065), la pista dalla cima a massa
RBAL ATT 0 1e12

* --- l'attenuatore a scatti da 10 k, scala in serie, e il cursore ---
RA ATT T1 1m
RB T1 T2 2.057k
RC T2 0 7.943k
SW1 T1 WIP NW1 0 SWK
SW2 T2 WIP NW2 0 SWK
VW1 NW1 0 PWL(0 1 1 1)
VW2 NW2 0 PWL(0 0 1 0)
* il cavo del cursore dal pannello alla scheda: la stessa ipotesi del cablaggio della cima
* (100 pF). Senza, col cursore aperto (m0) il gate del blocco B non ha nessuna capacita' verso
* massa e il simulatore lo porta a 0 V in < 30 us: un artefatto del banco (sonda L48b).
CWIP WIP 0 100p

* --- v1: il condensatore all'ingresso del blocco B, con la sua resistenza di gate ---
CB    WIP BIN 1p
RBYB  WIP BIN 1m
RGATE BIN 0 1e12

* --- il blocco B, 0 / +3 / +10 dB ---
XB BIN BOUT BFB BRG BRG10 VPLUS VMINUS GAINBLOCKB
CSTB    BRG   0 15p
RRGB    BRG   0 1G
CSTB10  BRG10 0 15p
RRG10B  BRG10 0 1G

RISO   BOUT BOUTA 47
COUT   BOUTA JACK 4.7u
RBLEED JACK 0 220k
RLOAD  JACK 0 100k

.control
set noaskquit
* gmin 1e-15: col default (1e-12 S su ogni giunzione) il gate-drain del JFET a ~14 V porta
* ~14 pA che il modello non ha, e col cursore aperto (m0) il gate derivava di 289 uV al jack
* (sonda L48b: 0,48 uV con 1e-15). La corrente di gate vera (datasheet) e' in analizza.py.
option itl1=1000 gmin=1e-15
echo "var,cap,va_mv,guad_db,evento,modo,va_misurata_mv,jack_prima_uv,pk_uv" > /Users/roberto/EDA/.claude/worktrees/L48b/docs/preamp/data/2026-10-07/L48b/scatti/deck/scatti_v4.csv

* ---- caso finale va=-6.6 g=0 ev=1 m=0
alter ca = 1p
alter rbya = 1m
alter ctx = 10u
alter rbyt = 1e12
alter cb = 1p
alter rbyb = 1m
alter rgate = 1Meg
alter rbal = 50k
alter vosa dc = -2.307e-05
alter iosa dc = -2.307e-11
alter rrgb = 1e+09
alter rrg10b = 1e+09
alter ra = 0.001
alter rb = 2056.72
alter rc = 7943.28
alter @vt1r[pwl] = [ 0 1 1 1 ]
alter @vt1s[pwl] = [ 0 0 1 0 ]
alter @vt2r[pwl] = [ 0 1 1 1 ]
alter @vt2s[pwl] = [ 0 0 1 0 ]
alter @vw1[pwl] = [ 0 1 0.02 1 0.020001 0 ]
alter @vw2[pwl] = [ 0 0 0.021 0 0.021001 1 ]
tran 20u 0.12 0 5e-06
meas tran vam find v(aout) at=0.018
meas tran jb find v(jack) at=0.0199
meas tran jmax max v(jack) from=0.0199 to=0.12
meas tran jmin min v(jack) from=0.0199 to=0.12
let vamv = vam*1e3
let jbu = jb*1e6
let pa = abs(jmax - jb)
let pb = abs(jmin - jb)
let pku = pa*1e6
if pb > pa
  let pku = pb*1e6
end
echo "4,finale,-6.6,0,1,0,$&vamv,$&jbu,$&pku" >> /Users/roberto/EDA/.claude/worktrees/L48b/docs/preamp/data/2026-10-07/L48b/scatti/deck/scatti_v4.csv
destroy all
* ---- caso finale va=-6.6 g=0 ev=1 m=1
alter ca = 1p
alter rbya = 1m
alter ctx = 10u
alter rbyt = 1e12
alter cb = 1p
alter rbyb = 1m
alter rgate = 1Meg
alter rbal = 50k
alter vosa dc = -2.307e-05
alter iosa dc = -2.307e-11
alter rrgb = 1e+09
alter rrg10b = 1e+09
alter ra = 0.001
alter rb = 2056.72
alter rc = 7943.28
alter @vt1r[pwl] = [ 0 1 1 1 ]
alter @vt1s[pwl] = [ 0 0 1 0 ]
alter @vt2r[pwl] = [ 0 1 1 1 ]
alter @vt2s[pwl] = [ 0 0 1 0 ]
alter @vw1[pwl] = [ 0 1 0.021 1 0.021001 0 ]
alter @vw2[pwl] = [ 0 0 0.02 0 0.020001 1 ]
tran 20u 0.12 0 5e-06
meas tran vam find v(aout) at=0.018
meas tran jb find v(jack) at=0.0199
meas tran jmax max v(jack) from=0.0199 to=0.12
meas tran jmin min v(jack) from=0.0199 to=0.12
let vamv = vam*1e3
let jbu = jb*1e6
let pa = abs(jmax - jb)
let pb = abs(jmin - jb)
let pku = pa*1e6
if pb > pa
  let pku = pb*1e6
end
echo "4,finale,-6.6,0,1,1,$&vamv,$&jbu,$&pku" >> /Users/roberto/EDA/.claude/worktrees/L48b/docs/preamp/data/2026-10-07/L48b/scatti/deck/scatti_v4.csv
destroy all
* ---- caso finale va=-6.6 g=0 ev=2 m=0
alter ca = 1p
alter rbya = 1m
alter ctx = 10u
alter rbyt = 1e12
alter cb = 1p
alter rbyb = 1m
alter rgate = 1Meg
alter rbal = 50k
alter vosa dc = -2.307e-05
alter iosa dc = -2.307e-11
alter rrgb = 1e+09
alter rrg10b = 1e+09
alter ra = 9553.32
alter rb = 91.8702
alter rc = 354.813
alter @vt1r[pwl] = [ 0 1 1 1 ]
alter @vt1s[pwl] = [ 0 0 1 0 ]
alter @vt2r[pwl] = [ 0 1 1 1 ]
alter @vt2s[pwl] = [ 0 0 1 0 ]
alter @vw1[pwl] = [ 0 0 0.021 0 0.021001 1 ]
alter @vw2[pwl] = [ 0 1 0.02 1 0.020001 0 ]
tran 20u 0.12 0 5e-06
meas tran vam find v(aout) at=0.018
meas tran jb find v(jack) at=0.0199
meas tran jmax max v(jack) from=0.0199 to=0.12
meas tran jmin min v(jack) from=0.0199 to=0.12
let vamv = vam*1e3
let jbu = jb*1e6
let pa = abs(jmax - jb)
let pb = abs(jmin - jb)
let pku = pa*1e6
if pb > pa
  let pku = pb*1e6
end
echo "4,finale,-6.6,0,2,0,$&vamv,$&jbu,$&pku" >> /Users/roberto/EDA/.claude/worktrees/L48b/docs/preamp/data/2026-10-07/L48b/scatti/deck/scatti_v4.csv
destroy all
* ---- caso finale va=-6.6 g=0 ev=2 m=1
alter ca = 1p
alter rbya = 1m
alter ctx = 10u
alter rbyt = 1e12
alter cb = 1p
alter rbyb = 1m
alter rgate = 1Meg
alter rbal = 50k
alter vosa dc = -2.307e-05
alter iosa dc = -2.307e-11
alter rrgb = 1e+09
alter rrg10b = 1e+09
alter ra = 9553.32
alter rb = 91.8702
alter rc = 354.813
alter @vt1r[pwl] = [ 0 1 1 1 ]
alter @vt1s[pwl] = [ 0 0 1 0 ]
alter @vt2r[pwl] = [ 0 1 1 1 ]
alter @vt2s[pwl] = [ 0 0 1 0 ]
alter @vw1[pwl] = [ 0 0 0.02 0 0.020001 1 ]
alter @vw2[pwl] = [ 0 1 0.021 1 0.021001 0 ]
tran 20u 0.12 0 5e-06
meas tran vam find v(aout) at=0.018
meas tran jb find v(jack) at=0.0199
meas tran jmax max v(jack) from=0.0199 to=0.12
meas tran jmin min v(jack) from=0.0199 to=0.12
let vamv = vam*1e3
let jbu = jb*1e6
let pa = abs(jmax - jb)
let pb = abs(jmin - jb)
let pku = pa*1e6
if pb > pa
  let pku = pb*1e6
end
echo "4,finale,-6.6,0,2,1,$&vamv,$&jbu,$&pku" >> /Users/roberto/EDA/.claude/worktrees/L48b/docs/preamp/data/2026-10-07/L48b/scatti/deck/scatti_v4.csv
destroy all
* ---- caso finale va=-6.6 g=0 ev=3 m=0
alter ca = 1p
alter rbya = 1m
alter ctx = 10u
alter rbyt = 1e12
alter cb = 1p
alter rbyb = 1m
alter rgate = 1Meg
alter rbal = 50k
alter vosa dc = -2.307e-05
alter iosa dc = -2.307e-11
alter rrgb = 1e+09
alter rrg10b = 1e+09
alter ra = 0.001
alter rb = 2056.72
alter rc = 7943.28
alter @vt1r[pwl] = [ 0 1 0.02 1 0.020001 0 ]
alter @vt1s[pwl] = [ 0 0 0.021 0 0.021001 1 ]
alter @vt2r[pwl] = [ 0 1 1 1 ]
alter @vt2s[pwl] = [ 0 0 1 0 ]
alter @vw1[pwl] = [ 0 1 1 1 ]
alter @vw2[pwl] = [ 0 0 1 0 ]
tran 20u 0.12 0 5e-06
meas tran vam find v(aout) at=0.018
meas tran jb find v(jack) at=0.0199
meas tran jmax max v(jack) from=0.0199 to=0.12
meas tran jmin min v(jack) from=0.0199 to=0.12
let vamv = vam*1e3
let jbu = jb*1e6
let pa = abs(jmax - jb)
let pb = abs(jmin - jb)
let pku = pa*1e6
if pb > pa
  let pku = pb*1e6
end
echo "4,finale,-6.6,0,3,0,$&vamv,$&jbu,$&pku" >> /Users/roberto/EDA/.claude/worktrees/L48b/docs/preamp/data/2026-10-07/L48b/scatti/deck/scatti_v4.csv
destroy all
* ---- caso finale va=-6.6 g=0 ev=4 m=0
alter ca = 1p
alter rbya = 1m
alter ctx = 10u
alter rbyt = 1e12
alter cb = 1p
alter rbyb = 1m
alter rgate = 1Meg
alter rbal = 50k
alter vosa dc = -2.307e-05
alter iosa dc = -2.307e-11
alter rrgb = 1e+09
alter rrg10b = 1e+09
alter ra = 0.001
alter rb = 2056.72
alter rc = 7943.28
alter @vt1r[pwl] = [ 0 0 1 0 ]
alter @vt1s[pwl] = [ 0 1 1 1 ]
alter @vt2r[pwl] = [ 0 1 0.02 1 0.020001 0 ]
alter @vt2s[pwl] = [ 0 0 0.021 0 0.021001 1 ]
alter @vw1[pwl] = [ 0 1 1 1 ]
alter @vw2[pwl] = [ 0 0 1 0 ]
tran 20u 0.12 0 5e-06
meas tran vam find v(aout) at=0.018
meas tran jb find v(jack) at=0.0199
meas tran jmax max v(jack) from=0.0199 to=0.12
meas tran jmin min v(jack) from=0.0199 to=0.12
let vamv = vam*1e3
let jbu = jb*1e6
let pa = abs(jmax - jb)
let pb = abs(jmin - jb)
let pku = pa*1e6
if pb > pa
  let pku = pb*1e6
end
echo "4,finale,-6.6,0,4,0,$&vamv,$&jbu,$&pku" >> /Users/roberto/EDA/.claude/worktrees/L48b/docs/preamp/data/2026-10-07/L48b/scatti/deck/scatti_v4.csv
destroy all
* ---- caso finale va=-6.6 g=3 ev=1 m=0
alter ca = 1p
alter rbya = 1m
alter ctx = 10u
alter rbyt = 1e12
alter cb = 1p
alter rbyb = 1m
alter rgate = 1Meg
alter rbal = 50k
alter vosa dc = -2.307e-05
alter iosa dc = -2.307e-11
alter rrgb = 0.1
alter rrg10b = 1e+09
alter ra = 0.001
alter rb = 2056.72
alter rc = 7943.28
alter @vt1r[pwl] = [ 0 1 1 1 ]
alter @vt1s[pwl] = [ 0 0 1 0 ]
alter @vt2r[pwl] = [ 0 1 1 1 ]
alter @vt2s[pwl] = [ 0 0 1 0 ]
alter @vw1[pwl] = [ 0 1 0.02 1 0.020001 0 ]
alter @vw2[pwl] = [ 0 0 0.021 0 0.021001 1 ]
tran 20u 0.12 0 5e-06
meas tran vam find v(aout) at=0.018
meas tran jb find v(jack) at=0.0199
meas tran jmax max v(jack) from=0.0199 to=0.12
meas tran jmin min v(jack) from=0.0199 to=0.12
let vamv = vam*1e3
let jbu = jb*1e6
let pa = abs(jmax - jb)
let pb = abs(jmin - jb)
let pku = pa*1e6
if pb > pa
  let pku = pb*1e6
end
echo "4,finale,-6.6,3,1,0,$&vamv,$&jbu,$&pku" >> /Users/roberto/EDA/.claude/worktrees/L48b/docs/preamp/data/2026-10-07/L48b/scatti/deck/scatti_v4.csv
destroy all
* ---- caso finale va=-6.6 g=3 ev=1 m=1
alter ca = 1p
alter rbya = 1m
alter ctx = 10u
alter rbyt = 1e12
alter cb = 1p
alter rbyb = 1m
alter rgate = 1Meg
alter rbal = 50k
alter vosa dc = -2.307e-05
alter iosa dc = -2.307e-11
alter rrgb = 0.1
alter rrg10b = 1e+09
alter ra = 0.001
alter rb = 2056.72
alter rc = 7943.28
alter @vt1r[pwl] = [ 0 1 1 1 ]
alter @vt1s[pwl] = [ 0 0 1 0 ]
alter @vt2r[pwl] = [ 0 1 1 1 ]
alter @vt2s[pwl] = [ 0 0 1 0 ]
alter @vw1[pwl] = [ 0 1 0.021 1 0.021001 0 ]
alter @vw2[pwl] = [ 0 0 0.02 0 0.020001 1 ]
tran 20u 0.12 0 5e-06
meas tran vam find v(aout) at=0.018
meas tran jb find v(jack) at=0.0199
meas tran jmax max v(jack) from=0.0199 to=0.12
meas tran jmin min v(jack) from=0.0199 to=0.12
let vamv = vam*1e3
let jbu = jb*1e6
let pa = abs(jmax - jb)
let pb = abs(jmin - jb)
let pku = pa*1e6
if pb > pa
  let pku = pb*1e6
end
echo "4,finale,-6.6,3,1,1,$&vamv,$&jbu,$&pku" >> /Users/roberto/EDA/.claude/worktrees/L48b/docs/preamp/data/2026-10-07/L48b/scatti/deck/scatti_v4.csv
destroy all
* ---- caso finale va=-6.6 g=3 ev=2 m=0
alter ca = 1p
alter rbya = 1m
alter ctx = 10u
alter rbyt = 1e12
alter cb = 1p
alter rbyb = 1m
alter rgate = 1Meg
alter rbal = 50k
alter vosa dc = -2.307e-05
alter iosa dc = -2.307e-11
alter rrgb = 0.1
alter rrg10b = 1e+09
alter ra = 9553.32
alter rb = 91.8702
alter rc = 354.813
alter @vt1r[pwl] = [ 0 1 1 1 ]
alter @vt1s[pwl] = [ 0 0 1 0 ]
alter @vt2r[pwl] = [ 0 1 1 1 ]
alter @vt2s[pwl] = [ 0 0 1 0 ]
alter @vw1[pwl] = [ 0 0 0.021 0 0.021001 1 ]
alter @vw2[pwl] = [ 0 1 0.02 1 0.020001 0 ]
tran 20u 0.12 0 5e-06
meas tran vam find v(aout) at=0.018
meas tran jb find v(jack) at=0.0199
meas tran jmax max v(jack) from=0.0199 to=0.12
meas tran jmin min v(jack) from=0.0199 to=0.12
let vamv = vam*1e3
let jbu = jb*1e6
let pa = abs(jmax - jb)
let pb = abs(jmin - jb)
let pku = pa*1e6
if pb > pa
  let pku = pb*1e6
end
echo "4,finale,-6.6,3,2,0,$&vamv,$&jbu,$&pku" >> /Users/roberto/EDA/.claude/worktrees/L48b/docs/preamp/data/2026-10-07/L48b/scatti/deck/scatti_v4.csv
destroy all
* ---- caso finale va=-6.6 g=3 ev=2 m=1
alter ca = 1p
alter rbya = 1m
alter ctx = 10u
alter rbyt = 1e12
alter cb = 1p
alter rbyb = 1m
alter rgate = 1Meg
alter rbal = 50k
alter vosa dc = -2.307e-05
alter iosa dc = -2.307e-11
alter rrgb = 0.1
alter rrg10b = 1e+09
alter ra = 9553.32
alter rb = 91.8702
alter rc = 354.813
alter @vt1r[pwl] = [ 0 1 1 1 ]
alter @vt1s[pwl] = [ 0 0 1 0 ]
alter @vt2r[pwl] = [ 0 1 1 1 ]
alter @vt2s[pwl] = [ 0 0 1 0 ]
alter @vw1[pwl] = [ 0 0 0.02 0 0.020001 1 ]
alter @vw2[pwl] = [ 0 1 0.021 1 0.021001 0 ]
tran 20u 0.12 0 5e-06
meas tran vam find v(aout) at=0.018
meas tran jb find v(jack) at=0.0199
meas tran jmax max v(jack) from=0.0199 to=0.12
meas tran jmin min v(jack) from=0.0199 to=0.12
let vamv = vam*1e3
let jbu = jb*1e6
let pa = abs(jmax - jb)
let pb = abs(jmin - jb)
let pku = pa*1e6
if pb > pa
  let pku = pb*1e6
end
echo "4,finale,-6.6,3,2,1,$&vamv,$&jbu,$&pku" >> /Users/roberto/EDA/.claude/worktrees/L48b/docs/preamp/data/2026-10-07/L48b/scatti/deck/scatti_v4.csv
destroy all
* ---- caso finale va=-6.6 g=3 ev=3 m=0
alter ca = 1p
alter rbya = 1m
alter ctx = 10u
alter rbyt = 1e12
alter cb = 1p
alter rbyb = 1m
alter rgate = 1Meg
alter rbal = 50k
alter vosa dc = -2.307e-05
alter iosa dc = -2.307e-11
alter rrgb = 0.1
alter rrg10b = 1e+09
alter ra = 0.001
alter rb = 2056.72
alter rc = 7943.28
alter @vt1r[pwl] = [ 0 1 0.02 1 0.020001 0 ]
alter @vt1s[pwl] = [ 0 0 0.021 0 0.021001 1 ]
alter @vt2r[pwl] = [ 0 1 1 1 ]
alter @vt2s[pwl] = [ 0 0 1 0 ]
alter @vw1[pwl] = [ 0 1 1 1 ]
alter @vw2[pwl] = [ 0 0 1 0 ]
tran 20u 0.12 0 5e-06
meas tran vam find v(aout) at=0.018
meas tran jb find v(jack) at=0.0199
meas tran jmax max v(jack) from=0.0199 to=0.12
meas tran jmin min v(jack) from=0.0199 to=0.12
let vamv = vam*1e3
let jbu = jb*1e6
let pa = abs(jmax - jb)
let pb = abs(jmin - jb)
let pku = pa*1e6
if pb > pa
  let pku = pb*1e6
end
echo "4,finale,-6.6,3,3,0,$&vamv,$&jbu,$&pku" >> /Users/roberto/EDA/.claude/worktrees/L48b/docs/preamp/data/2026-10-07/L48b/scatti/deck/scatti_v4.csv
destroy all
* ---- caso finale va=-6.6 g=3 ev=4 m=0
alter ca = 1p
alter rbya = 1m
alter ctx = 10u
alter rbyt = 1e12
alter cb = 1p
alter rbyb = 1m
alter rgate = 1Meg
alter rbal = 50k
alter vosa dc = -2.307e-05
alter iosa dc = -2.307e-11
alter rrgb = 0.1
alter rrg10b = 1e+09
alter ra = 0.001
alter rb = 2056.72
alter rc = 7943.28
alter @vt1r[pwl] = [ 0 0 1 0 ]
alter @vt1s[pwl] = [ 0 1 1 1 ]
alter @vt2r[pwl] = [ 0 1 0.02 1 0.020001 0 ]
alter @vt2s[pwl] = [ 0 0 0.021 0 0.021001 1 ]
alter @vw1[pwl] = [ 0 1 1 1 ]
alter @vw2[pwl] = [ 0 0 1 0 ]
tran 20u 0.12 0 5e-06
meas tran vam find v(aout) at=0.018
meas tran jb find v(jack) at=0.0199
meas tran jmax max v(jack) from=0.0199 to=0.12
meas tran jmin min v(jack) from=0.0199 to=0.12
let vamv = vam*1e3
let jbu = jb*1e6
let pa = abs(jmax - jb)
let pb = abs(jmin - jb)
let pku = pa*1e6
if pb > pa
  let pku = pb*1e6
end
echo "4,finale,-6.6,3,4,0,$&vamv,$&jbu,$&pku" >> /Users/roberto/EDA/.claude/worktrees/L48b/docs/preamp/data/2026-10-07/L48b/scatti/deck/scatti_v4.csv
destroy all
* ---- caso finale va=-6.6 g=10 ev=1 m=0
alter ca = 1p
alter rbya = 1m
alter ctx = 10u
alter rbyt = 1e12
alter cb = 1p
alter rbyb = 1m
alter rgate = 1Meg
alter rbal = 50k
alter vosa dc = -2.307e-05
alter iosa dc = -2.307e-11
alter rrgb = 0.1
alter rrg10b = 0.1
alter ra = 0.001
alter rb = 2056.72
alter rc = 7943.28
alter @vt1r[pwl] = [ 0 1 1 1 ]
alter @vt1s[pwl] = [ 0 0 1 0 ]
alter @vt2r[pwl] = [ 0 1 1 1 ]
alter @vt2s[pwl] = [ 0 0 1 0 ]
alter @vw1[pwl] = [ 0 1 0.02 1 0.020001 0 ]
alter @vw2[pwl] = [ 0 0 0.021 0 0.021001 1 ]
tran 20u 0.12 0 5e-06
meas tran vam find v(aout) at=0.018
meas tran jb find v(jack) at=0.0199
meas tran jmax max v(jack) from=0.0199 to=0.12
meas tran jmin min v(jack) from=0.0199 to=0.12
let vamv = vam*1e3
let jbu = jb*1e6
let pa = abs(jmax - jb)
let pb = abs(jmin - jb)
let pku = pa*1e6
if pb > pa
  let pku = pb*1e6
end
echo "4,finale,-6.6,10,1,0,$&vamv,$&jbu,$&pku" >> /Users/roberto/EDA/.claude/worktrees/L48b/docs/preamp/data/2026-10-07/L48b/scatti/deck/scatti_v4.csv
destroy all
* ---- caso finale va=-6.6 g=10 ev=1 m=1
alter ca = 1p
alter rbya = 1m
alter ctx = 10u
alter rbyt = 1e12
alter cb = 1p
alter rbyb = 1m
alter rgate = 1Meg
alter rbal = 50k
alter vosa dc = -2.307e-05
alter iosa dc = -2.307e-11
alter rrgb = 0.1
alter rrg10b = 0.1
alter ra = 0.001
alter rb = 2056.72
alter rc = 7943.28
alter @vt1r[pwl] = [ 0 1 1 1 ]
alter @vt1s[pwl] = [ 0 0 1 0 ]
alter @vt2r[pwl] = [ 0 1 1 1 ]
alter @vt2s[pwl] = [ 0 0 1 0 ]
alter @vw1[pwl] = [ 0 1 0.021 1 0.021001 0 ]
alter @vw2[pwl] = [ 0 0 0.02 0 0.020001 1 ]
tran 20u 0.12 0 5e-06
meas tran vam find v(aout) at=0.018
meas tran jb find v(jack) at=0.0199
meas tran jmax max v(jack) from=0.0199 to=0.12
meas tran jmin min v(jack) from=0.0199 to=0.12
let vamv = vam*1e3
let jbu = jb*1e6
let pa = abs(jmax - jb)
let pb = abs(jmin - jb)
let pku = pa*1e6
if pb > pa
  let pku = pb*1e6
end
echo "4,finale,-6.6,10,1,1,$&vamv,$&jbu,$&pku" >> /Users/roberto/EDA/.claude/worktrees/L48b/docs/preamp/data/2026-10-07/L48b/scatti/deck/scatti_v4.csv
destroy all
* ---- caso finale va=-6.6 g=10 ev=2 m=0
alter ca = 1p
alter rbya = 1m
alter ctx = 10u
alter rbyt = 1e12
alter cb = 1p
alter rbyb = 1m
alter rgate = 1Meg
alter rbal = 50k
alter vosa dc = -2.307e-05
alter iosa dc = -2.307e-11
alter rrgb = 0.1
alter rrg10b = 0.1
alter ra = 9553.32
alter rb = 91.8702
alter rc = 354.813
alter @vt1r[pwl] = [ 0 1 1 1 ]
alter @vt1s[pwl] = [ 0 0 1 0 ]
alter @vt2r[pwl] = [ 0 1 1 1 ]
alter @vt2s[pwl] = [ 0 0 1 0 ]
alter @vw1[pwl] = [ 0 0 0.021 0 0.021001 1 ]
alter @vw2[pwl] = [ 0 1 0.02 1 0.020001 0 ]
tran 20u 0.12 0 5e-06
meas tran vam find v(aout) at=0.018
meas tran jb find v(jack) at=0.0199
meas tran jmax max v(jack) from=0.0199 to=0.12
meas tran jmin min v(jack) from=0.0199 to=0.12
let vamv = vam*1e3
let jbu = jb*1e6
let pa = abs(jmax - jb)
let pb = abs(jmin - jb)
let pku = pa*1e6
if pb > pa
  let pku = pb*1e6
end
echo "4,finale,-6.6,10,2,0,$&vamv,$&jbu,$&pku" >> /Users/roberto/EDA/.claude/worktrees/L48b/docs/preamp/data/2026-10-07/L48b/scatti/deck/scatti_v4.csv
destroy all
* ---- caso finale va=-6.6 g=10 ev=2 m=1
alter ca = 1p
alter rbya = 1m
alter ctx = 10u
alter rbyt = 1e12
alter cb = 1p
alter rbyb = 1m
alter rgate = 1Meg
alter rbal = 50k
alter vosa dc = -2.307e-05
alter iosa dc = -2.307e-11
alter rrgb = 0.1
alter rrg10b = 0.1
alter ra = 9553.32
alter rb = 91.8702
alter rc = 354.813
alter @vt1r[pwl] = [ 0 1 1 1 ]
alter @vt1s[pwl] = [ 0 0 1 0 ]
alter @vt2r[pwl] = [ 0 1 1 1 ]
alter @vt2s[pwl] = [ 0 0 1 0 ]
alter @vw1[pwl] = [ 0 0 0.02 0 0.020001 1 ]
alter @vw2[pwl] = [ 0 1 0.021 1 0.021001 0 ]
tran 20u 0.12 0 5e-06
meas tran vam find v(aout) at=0.018
meas tran jb find v(jack) at=0.0199
meas tran jmax max v(jack) from=0.0199 to=0.12
meas tran jmin min v(jack) from=0.0199 to=0.12
let vamv = vam*1e3
let jbu = jb*1e6
let pa = abs(jmax - jb)
let pb = abs(jmin - jb)
let pku = pa*1e6
if pb > pa
  let pku = pb*1e6
end
echo "4,finale,-6.6,10,2,1,$&vamv,$&jbu,$&pku" >> /Users/roberto/EDA/.claude/worktrees/L48b/docs/preamp/data/2026-10-07/L48b/scatti/deck/scatti_v4.csv
destroy all
* ---- caso finale va=-6.6 g=10 ev=3 m=0
alter ca = 1p
alter rbya = 1m
alter ctx = 10u
alter rbyt = 1e12
alter cb = 1p
alter rbyb = 1m
alter rgate = 1Meg
alter rbal = 50k
alter vosa dc = -2.307e-05
alter iosa dc = -2.307e-11
alter rrgb = 0.1
alter rrg10b = 0.1
alter ra = 0.001
alter rb = 2056.72
alter rc = 7943.28
alter @vt1r[pwl] = [ 0 1 0.02 1 0.020001 0 ]
alter @vt1s[pwl] = [ 0 0 0.021 0 0.021001 1 ]
alter @vt2r[pwl] = [ 0 1 1 1 ]
alter @vt2s[pwl] = [ 0 0 1 0 ]
alter @vw1[pwl] = [ 0 1 1 1 ]
alter @vw2[pwl] = [ 0 0 1 0 ]
tran 20u 0.12 0 5e-06
meas tran vam find v(aout) at=0.018
meas tran jb find v(jack) at=0.0199
meas tran jmax max v(jack) from=0.0199 to=0.12
meas tran jmin min v(jack) from=0.0199 to=0.12
let vamv = vam*1e3
let jbu = jb*1e6
let pa = abs(jmax - jb)
let pb = abs(jmin - jb)
let pku = pa*1e6
if pb > pa
  let pku = pb*1e6
end
echo "4,finale,-6.6,10,3,0,$&vamv,$&jbu,$&pku" >> /Users/roberto/EDA/.claude/worktrees/L48b/docs/preamp/data/2026-10-07/L48b/scatti/deck/scatti_v4.csv
destroy all
* ---- caso finale va=-6.6 g=10 ev=4 m=0
alter ca = 1p
alter rbya = 1m
alter ctx = 10u
alter rbyt = 1e12
alter cb = 1p
alter rbyb = 1m
alter rgate = 1Meg
alter rbal = 50k
alter vosa dc = -2.307e-05
alter iosa dc = -2.307e-11
alter rrgb = 0.1
alter rrg10b = 0.1
alter ra = 0.001
alter rb = 2056.72
alter rc = 7943.28
alter @vt1r[pwl] = [ 0 0 1 0 ]
alter @vt1s[pwl] = [ 0 1 1 1 ]
alter @vt2r[pwl] = [ 0 1 0.02 1 0.020001 0 ]
alter @vt2s[pwl] = [ 0 0 0.021 0 0.021001 1 ]
alter @vw1[pwl] = [ 0 1 1 1 ]
alter @vw2[pwl] = [ 0 0 1 0 ]
tran 20u 0.12 0 5e-06
meas tran vam find v(aout) at=0.018
meas tran jb find v(jack) at=0.0199
meas tran jmax max v(jack) from=0.0199 to=0.12
meas tran jmin min v(jack) from=0.0199 to=0.12
let vamv = vam*1e3
let jbu = jb*1e6
let pa = abs(jmax - jb)
let pb = abs(jmin - jb)
let pku = pa*1e6
if pb > pa
  let pku = pb*1e6
end
echo "4,finale,-6.6,10,4,0,$&vamv,$&jbu,$&pku" >> /Users/roberto/EDA/.claude/worktrees/L48b/docs/preamp/data/2026-10-07/L48b/scatti/deck/scatti_v4.csv
destroy all
* ---- caso finale va=-30 g=0 ev=1 m=0
alter ca = 1p
alter rbya = 1m
alter ctx = 10u
alter rbyt = 1e12
alter cb = 1p
alter rbyb = 1m
alter rgate = 1Meg
alter rbal = 50k
alter vosa dc = 0.0233769
alter iosa dc = 2.33769e-08
alter rrgb = 1e+09
alter rrg10b = 1e+09
alter ra = 0.001
alter rb = 2056.72
alter rc = 7943.28
alter @vt1r[pwl] = [ 0 1 1 1 ]
alter @vt1s[pwl] = [ 0 0 1 0 ]
alter @vt2r[pwl] = [ 0 1 1 1 ]
alter @vt2s[pwl] = [ 0 0 1 0 ]
alter @vw1[pwl] = [ 0 1 0.02 1 0.020001 0 ]
alter @vw2[pwl] = [ 0 0 0.021 0 0.021001 1 ]
tran 20u 0.12 0 5e-06
meas tran vam find v(aout) at=0.018
meas tran jb find v(jack) at=0.0199
meas tran jmax max v(jack) from=0.0199 to=0.12
meas tran jmin min v(jack) from=0.0199 to=0.12
let vamv = vam*1e3
let jbu = jb*1e6
let pa = abs(jmax - jb)
let pb = abs(jmin - jb)
let pku = pa*1e6
if pb > pa
  let pku = pb*1e6
end
echo "4,finale,-30,0,1,0,$&vamv,$&jbu,$&pku" >> /Users/roberto/EDA/.claude/worktrees/L48b/docs/preamp/data/2026-10-07/L48b/scatti/deck/scatti_v4.csv
destroy all
* ---- caso finale va=-30 g=0 ev=1 m=1
alter ca = 1p
alter rbya = 1m
alter ctx = 10u
alter rbyt = 1e12
alter cb = 1p
alter rbyb = 1m
alter rgate = 1Meg
alter rbal = 50k
alter vosa dc = 0.0233769
alter iosa dc = 2.33769e-08
alter rrgb = 1e+09
alter rrg10b = 1e+09
alter ra = 0.001
alter rb = 2056.72
alter rc = 7943.28
alter @vt1r[pwl] = [ 0 1 1 1 ]
alter @vt1s[pwl] = [ 0 0 1 0 ]
alter @vt2r[pwl] = [ 0 1 1 1 ]
alter @vt2s[pwl] = [ 0 0 1 0 ]
alter @vw1[pwl] = [ 0 1 0.021 1 0.021001 0 ]
alter @vw2[pwl] = [ 0 0 0.02 0 0.020001 1 ]
tran 20u 0.12 0 5e-06
meas tran vam find v(aout) at=0.018
meas tran jb find v(jack) at=0.0199
meas tran jmax max v(jack) from=0.0199 to=0.12
meas tran jmin min v(jack) from=0.0199 to=0.12
let vamv = vam*1e3
let jbu = jb*1e6
let pa = abs(jmax - jb)
let pb = abs(jmin - jb)
let pku = pa*1e6
if pb > pa
  let pku = pb*1e6
end
echo "4,finale,-30,0,1,1,$&vamv,$&jbu,$&pku" >> /Users/roberto/EDA/.claude/worktrees/L48b/docs/preamp/data/2026-10-07/L48b/scatti/deck/scatti_v4.csv
destroy all
* ---- caso finale va=-30 g=0 ev=2 m=0
alter ca = 1p
alter rbya = 1m
alter ctx = 10u
alter rbyt = 1e12
alter cb = 1p
alter rbyb = 1m
alter rgate = 1Meg
alter rbal = 50k
alter vosa dc = 0.0233769
alter iosa dc = 2.33769e-08
alter rrgb = 1e+09
alter rrg10b = 1e+09
alter ra = 9553.32
alter rb = 91.8702
alter rc = 354.813
alter @vt1r[pwl] = [ 0 1 1 1 ]
alter @vt1s[pwl] = [ 0 0 1 0 ]
alter @vt2r[pwl] = [ 0 1 1 1 ]
alter @vt2s[pwl] = [ 0 0 1 0 ]
alter @vw1[pwl] = [ 0 0 0.021 0 0.021001 1 ]
alter @vw2[pwl] = [ 0 1 0.02 1 0.020001 0 ]
tran 20u 0.12 0 5e-06
meas tran vam find v(aout) at=0.018
meas tran jb find v(jack) at=0.0199
meas tran jmax max v(jack) from=0.0199 to=0.12
meas tran jmin min v(jack) from=0.0199 to=0.12
let vamv = vam*1e3
let jbu = jb*1e6
let pa = abs(jmax - jb)
let pb = abs(jmin - jb)
let pku = pa*1e6
if pb > pa
  let pku = pb*1e6
end
echo "4,finale,-30,0,2,0,$&vamv,$&jbu,$&pku" >> /Users/roberto/EDA/.claude/worktrees/L48b/docs/preamp/data/2026-10-07/L48b/scatti/deck/scatti_v4.csv
destroy all
* ---- caso finale va=-30 g=0 ev=2 m=1
alter ca = 1p
alter rbya = 1m
alter ctx = 10u
alter rbyt = 1e12
alter cb = 1p
alter rbyb = 1m
alter rgate = 1Meg
alter rbal = 50k
alter vosa dc = 0.0233769
alter iosa dc = 2.33769e-08
alter rrgb = 1e+09
alter rrg10b = 1e+09
alter ra = 9553.32
alter rb = 91.8702
alter rc = 354.813
alter @vt1r[pwl] = [ 0 1 1 1 ]
alter @vt1s[pwl] = [ 0 0 1 0 ]
alter @vt2r[pwl] = [ 0 1 1 1 ]
alter @vt2s[pwl] = [ 0 0 1 0 ]
alter @vw1[pwl] = [ 0 0 0.02 0 0.020001 1 ]
alter @vw2[pwl] = [ 0 1 0.021 1 0.021001 0 ]
tran 20u 0.12 0 5e-06
meas tran vam find v(aout) at=0.018
meas tran jb find v(jack) at=0.0199
meas tran jmax max v(jack) from=0.0199 to=0.12
meas tran jmin min v(jack) from=0.0199 to=0.12
let vamv = vam*1e3
let jbu = jb*1e6
let pa = abs(jmax - jb)
let pb = abs(jmin - jb)
let pku = pa*1e6
if pb > pa
  let pku = pb*1e6
end
echo "4,finale,-30,0,2,1,$&vamv,$&jbu,$&pku" >> /Users/roberto/EDA/.claude/worktrees/L48b/docs/preamp/data/2026-10-07/L48b/scatti/deck/scatti_v4.csv
destroy all
* ---- caso finale va=-30 g=0 ev=3 m=0
alter ca = 1p
alter rbya = 1m
alter ctx = 10u
alter rbyt = 1e12
alter cb = 1p
alter rbyb = 1m
alter rgate = 1Meg
alter rbal = 50k
alter vosa dc = 0.0233769
alter iosa dc = 2.33769e-08
alter rrgb = 1e+09
alter rrg10b = 1e+09
alter ra = 0.001
alter rb = 2056.72
alter rc = 7943.28
alter @vt1r[pwl] = [ 0 1 0.02 1 0.020001 0 ]
alter @vt1s[pwl] = [ 0 0 0.021 0 0.021001 1 ]
alter @vt2r[pwl] = [ 0 1 1 1 ]
alter @vt2s[pwl] = [ 0 0 1 0 ]
alter @vw1[pwl] = [ 0 1 1 1 ]
alter @vw2[pwl] = [ 0 0 1 0 ]
tran 20u 0.12 0 5e-06
meas tran vam find v(aout) at=0.018
meas tran jb find v(jack) at=0.0199
meas tran jmax max v(jack) from=0.0199 to=0.12
meas tran jmin min v(jack) from=0.0199 to=0.12
let vamv = vam*1e3
let jbu = jb*1e6
let pa = abs(jmax - jb)
let pb = abs(jmin - jb)
let pku = pa*1e6
if pb > pa
  let pku = pb*1e6
end
echo "4,finale,-30,0,3,0,$&vamv,$&jbu,$&pku" >> /Users/roberto/EDA/.claude/worktrees/L48b/docs/preamp/data/2026-10-07/L48b/scatti/deck/scatti_v4.csv
destroy all
* ---- caso finale va=-30 g=0 ev=4 m=0
alter ca = 1p
alter rbya = 1m
alter ctx = 10u
alter rbyt = 1e12
alter cb = 1p
alter rbyb = 1m
alter rgate = 1Meg
alter rbal = 50k
alter vosa dc = 0.0233769
alter iosa dc = 2.33769e-08
alter rrgb = 1e+09
alter rrg10b = 1e+09
alter ra = 0.001
alter rb = 2056.72
alter rc = 7943.28
alter @vt1r[pwl] = [ 0 0 1 0 ]
alter @vt1s[pwl] = [ 0 1 1 1 ]
alter @vt2r[pwl] = [ 0 1 0.02 1 0.020001 0 ]
alter @vt2s[pwl] = [ 0 0 0.021 0 0.021001 1 ]
alter @vw1[pwl] = [ 0 1 1 1 ]
alter @vw2[pwl] = [ 0 0 1 0 ]
tran 20u 0.12 0 5e-06
meas tran vam find v(aout) at=0.018
meas tran jb find v(jack) at=0.0199
meas tran jmax max v(jack) from=0.0199 to=0.12
meas tran jmin min v(jack) from=0.0199 to=0.12
let vamv = vam*1e3
let jbu = jb*1e6
let pa = abs(jmax - jb)
let pb = abs(jmin - jb)
let pku = pa*1e6
if pb > pa
  let pku = pb*1e6
end
echo "4,finale,-30,0,4,0,$&vamv,$&jbu,$&pku" >> /Users/roberto/EDA/.claude/worktrees/L48b/docs/preamp/data/2026-10-07/L48b/scatti/deck/scatti_v4.csv
destroy all
* ---- caso finale va=-30 g=3 ev=1 m=0
alter ca = 1p
alter rbya = 1m
alter ctx = 10u
alter rbyt = 1e12
alter cb = 1p
alter rbyb = 1m
alter rgate = 1Meg
alter rbal = 50k
alter vosa dc = 0.0233769
alter iosa dc = 2.33769e-08
alter rrgb = 0.1
alter rrg10b = 1e+09
alter ra = 0.001
alter rb = 2056.72
alter rc = 7943.28
alter @vt1r[pwl] = [ 0 1 1 1 ]
alter @vt1s[pwl] = [ 0 0 1 0 ]
alter @vt2r[pwl] = [ 0 1 1 1 ]
alter @vt2s[pwl] = [ 0 0 1 0 ]
alter @vw1[pwl] = [ 0 1 0.02 1 0.020001 0 ]
alter @vw2[pwl] = [ 0 0 0.021 0 0.021001 1 ]
tran 20u 0.12 0 5e-06
meas tran vam find v(aout) at=0.018
meas tran jb find v(jack) at=0.0199
meas tran jmax max v(jack) from=0.0199 to=0.12
meas tran jmin min v(jack) from=0.0199 to=0.12
let vamv = vam*1e3
let jbu = jb*1e6
let pa = abs(jmax - jb)
let pb = abs(jmin - jb)
let pku = pa*1e6
if pb > pa
  let pku = pb*1e6
end
echo "4,finale,-30,3,1,0,$&vamv,$&jbu,$&pku" >> /Users/roberto/EDA/.claude/worktrees/L48b/docs/preamp/data/2026-10-07/L48b/scatti/deck/scatti_v4.csv
destroy all
* ---- caso finale va=-30 g=3 ev=1 m=1
alter ca = 1p
alter rbya = 1m
alter ctx = 10u
alter rbyt = 1e12
alter cb = 1p
alter rbyb = 1m
alter rgate = 1Meg
alter rbal = 50k
alter vosa dc = 0.0233769
alter iosa dc = 2.33769e-08
alter rrgb = 0.1
alter rrg10b = 1e+09
alter ra = 0.001
alter rb = 2056.72
alter rc = 7943.28
alter @vt1r[pwl] = [ 0 1 1 1 ]
alter @vt1s[pwl] = [ 0 0 1 0 ]
alter @vt2r[pwl] = [ 0 1 1 1 ]
alter @vt2s[pwl] = [ 0 0 1 0 ]
alter @vw1[pwl] = [ 0 1 0.021 1 0.021001 0 ]
alter @vw2[pwl] = [ 0 0 0.02 0 0.020001 1 ]
tran 20u 0.12 0 5e-06
meas tran vam find v(aout) at=0.018
meas tran jb find v(jack) at=0.0199
meas tran jmax max v(jack) from=0.0199 to=0.12
meas tran jmin min v(jack) from=0.0199 to=0.12
let vamv = vam*1e3
let jbu = jb*1e6
let pa = abs(jmax - jb)
let pb = abs(jmin - jb)
let pku = pa*1e6
if pb > pa
  let pku = pb*1e6
end
echo "4,finale,-30,3,1,1,$&vamv,$&jbu,$&pku" >> /Users/roberto/EDA/.claude/worktrees/L48b/docs/preamp/data/2026-10-07/L48b/scatti/deck/scatti_v4.csv
destroy all
* ---- caso finale va=-30 g=3 ev=2 m=0
alter ca = 1p
alter rbya = 1m
alter ctx = 10u
alter rbyt = 1e12
alter cb = 1p
alter rbyb = 1m
alter rgate = 1Meg
alter rbal = 50k
alter vosa dc = 0.0233769
alter iosa dc = 2.33769e-08
alter rrgb = 0.1
alter rrg10b = 1e+09
alter ra = 9553.32
alter rb = 91.8702
alter rc = 354.813
alter @vt1r[pwl] = [ 0 1 1 1 ]
alter @vt1s[pwl] = [ 0 0 1 0 ]
alter @vt2r[pwl] = [ 0 1 1 1 ]
alter @vt2s[pwl] = [ 0 0 1 0 ]
alter @vw1[pwl] = [ 0 0 0.021 0 0.021001 1 ]
alter @vw2[pwl] = [ 0 1 0.02 1 0.020001 0 ]
tran 20u 0.12 0 5e-06
meas tran vam find v(aout) at=0.018
meas tran jb find v(jack) at=0.0199
meas tran jmax max v(jack) from=0.0199 to=0.12
meas tran jmin min v(jack) from=0.0199 to=0.12
let vamv = vam*1e3
let jbu = jb*1e6
let pa = abs(jmax - jb)
let pb = abs(jmin - jb)
let pku = pa*1e6
if pb > pa
  let pku = pb*1e6
end
echo "4,finale,-30,3,2,0,$&vamv,$&jbu,$&pku" >> /Users/roberto/EDA/.claude/worktrees/L48b/docs/preamp/data/2026-10-07/L48b/scatti/deck/scatti_v4.csv
destroy all
* ---- caso finale va=-30 g=3 ev=2 m=1
alter ca = 1p
alter rbya = 1m
alter ctx = 10u
alter rbyt = 1e12
alter cb = 1p
alter rbyb = 1m
alter rgate = 1Meg
alter rbal = 50k
alter vosa dc = 0.0233769
alter iosa dc = 2.33769e-08
alter rrgb = 0.1
alter rrg10b = 1e+09
alter ra = 9553.32
alter rb = 91.8702
alter rc = 354.813
alter @vt1r[pwl] = [ 0 1 1 1 ]
alter @vt1s[pwl] = [ 0 0 1 0 ]
alter @vt2r[pwl] = [ 0 1 1 1 ]
alter @vt2s[pwl] = [ 0 0 1 0 ]
alter @vw1[pwl] = [ 0 0 0.02 0 0.020001 1 ]
alter @vw2[pwl] = [ 0 1 0.021 1 0.021001 0 ]
tran 20u 0.12 0 5e-06
meas tran vam find v(aout) at=0.018
meas tran jb find v(jack) at=0.0199
meas tran jmax max v(jack) from=0.0199 to=0.12
meas tran jmin min v(jack) from=0.0199 to=0.12
let vamv = vam*1e3
let jbu = jb*1e6
let pa = abs(jmax - jb)
let pb = abs(jmin - jb)
let pku = pa*1e6
if pb > pa
  let pku = pb*1e6
end
echo "4,finale,-30,3,2,1,$&vamv,$&jbu,$&pku" >> /Users/roberto/EDA/.claude/worktrees/L48b/docs/preamp/data/2026-10-07/L48b/scatti/deck/scatti_v4.csv
destroy all
* ---- caso finale va=-30 g=3 ev=3 m=0
alter ca = 1p
alter rbya = 1m
alter ctx = 10u
alter rbyt = 1e12
alter cb = 1p
alter rbyb = 1m
alter rgate = 1Meg
alter rbal = 50k
alter vosa dc = 0.0233769
alter iosa dc = 2.33769e-08
alter rrgb = 0.1
alter rrg10b = 1e+09
alter ra = 0.001
alter rb = 2056.72
alter rc = 7943.28
alter @vt1r[pwl] = [ 0 1 0.02 1 0.020001 0 ]
alter @vt1s[pwl] = [ 0 0 0.021 0 0.021001 1 ]
alter @vt2r[pwl] = [ 0 1 1 1 ]
alter @vt2s[pwl] = [ 0 0 1 0 ]
alter @vw1[pwl] = [ 0 1 1 1 ]
alter @vw2[pwl] = [ 0 0 1 0 ]
tran 20u 0.12 0 5e-06
meas tran vam find v(aout) at=0.018
meas tran jb find v(jack) at=0.0199
meas tran jmax max v(jack) from=0.0199 to=0.12
meas tran jmin min v(jack) from=0.0199 to=0.12
let vamv = vam*1e3
let jbu = jb*1e6
let pa = abs(jmax - jb)
let pb = abs(jmin - jb)
let pku = pa*1e6
if pb > pa
  let pku = pb*1e6
end
echo "4,finale,-30,3,3,0,$&vamv,$&jbu,$&pku" >> /Users/roberto/EDA/.claude/worktrees/L48b/docs/preamp/data/2026-10-07/L48b/scatti/deck/scatti_v4.csv
destroy all
* ---- caso finale va=-30 g=3 ev=4 m=0
alter ca = 1p
alter rbya = 1m
alter ctx = 10u
alter rbyt = 1e12
alter cb = 1p
alter rbyb = 1m
alter rgate = 1Meg
alter rbal = 50k
alter vosa dc = 0.0233769
alter iosa dc = 2.33769e-08
alter rrgb = 0.1
alter rrg10b = 1e+09
alter ra = 0.001
alter rb = 2056.72
alter rc = 7943.28
alter @vt1r[pwl] = [ 0 0 1 0 ]
alter @vt1s[pwl] = [ 0 1 1 1 ]
alter @vt2r[pwl] = [ 0 1 0.02 1 0.020001 0 ]
alter @vt2s[pwl] = [ 0 0 0.021 0 0.021001 1 ]
alter @vw1[pwl] = [ 0 1 1 1 ]
alter @vw2[pwl] = [ 0 0 1 0 ]
tran 20u 0.12 0 5e-06
meas tran vam find v(aout) at=0.018
meas tran jb find v(jack) at=0.0199
meas tran jmax max v(jack) from=0.0199 to=0.12
meas tran jmin min v(jack) from=0.0199 to=0.12
let vamv = vam*1e3
let jbu = jb*1e6
let pa = abs(jmax - jb)
let pb = abs(jmin - jb)
let pku = pa*1e6
if pb > pa
  let pku = pb*1e6
end
echo "4,finale,-30,3,4,0,$&vamv,$&jbu,$&pku" >> /Users/roberto/EDA/.claude/worktrees/L48b/docs/preamp/data/2026-10-07/L48b/scatti/deck/scatti_v4.csv
destroy all
* ---- caso finale va=-30 g=10 ev=1 m=0
alter ca = 1p
alter rbya = 1m
alter ctx = 10u
alter rbyt = 1e12
alter cb = 1p
alter rbyb = 1m
alter rgate = 1Meg
alter rbal = 50k
alter vosa dc = 0.0233769
alter iosa dc = 2.33769e-08
alter rrgb = 0.1
alter rrg10b = 0.1
alter ra = 0.001
alter rb = 2056.72
alter rc = 7943.28
alter @vt1r[pwl] = [ 0 1 1 1 ]
alter @vt1s[pwl] = [ 0 0 1 0 ]
alter @vt2r[pwl] = [ 0 1 1 1 ]
alter @vt2s[pwl] = [ 0 0 1 0 ]
alter @vw1[pwl] = [ 0 1 0.02 1 0.020001 0 ]
alter @vw2[pwl] = [ 0 0 0.021 0 0.021001 1 ]
tran 20u 0.12 0 5e-06
meas tran vam find v(aout) at=0.018
meas tran jb find v(jack) at=0.0199
meas tran jmax max v(jack) from=0.0199 to=0.12
meas tran jmin min v(jack) from=0.0199 to=0.12
let vamv = vam*1e3
let jbu = jb*1e6
let pa = abs(jmax - jb)
let pb = abs(jmin - jb)
let pku = pa*1e6
if pb > pa
  let pku = pb*1e6
end
echo "4,finale,-30,10,1,0,$&vamv,$&jbu,$&pku" >> /Users/roberto/EDA/.claude/worktrees/L48b/docs/preamp/data/2026-10-07/L48b/scatti/deck/scatti_v4.csv
destroy all
* ---- caso finale va=-30 g=10 ev=1 m=1
alter ca = 1p
alter rbya = 1m
alter ctx = 10u
alter rbyt = 1e12
alter cb = 1p
alter rbyb = 1m
alter rgate = 1Meg
alter rbal = 50k
alter vosa dc = 0.0233769
alter iosa dc = 2.33769e-08
alter rrgb = 0.1
alter rrg10b = 0.1
alter ra = 0.001
alter rb = 2056.72
alter rc = 7943.28
alter @vt1r[pwl] = [ 0 1 1 1 ]
alter @vt1s[pwl] = [ 0 0 1 0 ]
alter @vt2r[pwl] = [ 0 1 1 1 ]
alter @vt2s[pwl] = [ 0 0 1 0 ]
alter @vw1[pwl] = [ 0 1 0.021 1 0.021001 0 ]
alter @vw2[pwl] = [ 0 0 0.02 0 0.020001 1 ]
tran 20u 0.12 0 5e-06
meas tran vam find v(aout) at=0.018
meas tran jb find v(jack) at=0.0199
meas tran jmax max v(jack) from=0.0199 to=0.12
meas tran jmin min v(jack) from=0.0199 to=0.12
let vamv = vam*1e3
let jbu = jb*1e6
let pa = abs(jmax - jb)
let pb = abs(jmin - jb)
let pku = pa*1e6
if pb > pa
  let pku = pb*1e6
end
echo "4,finale,-30,10,1,1,$&vamv,$&jbu,$&pku" >> /Users/roberto/EDA/.claude/worktrees/L48b/docs/preamp/data/2026-10-07/L48b/scatti/deck/scatti_v4.csv
destroy all
* ---- caso finale va=-30 g=10 ev=2 m=0
alter ca = 1p
alter rbya = 1m
alter ctx = 10u
alter rbyt = 1e12
alter cb = 1p
alter rbyb = 1m
alter rgate = 1Meg
alter rbal = 50k
alter vosa dc = 0.0233769
alter iosa dc = 2.33769e-08
alter rrgb = 0.1
alter rrg10b = 0.1
alter ra = 9553.32
alter rb = 91.8702
alter rc = 354.813
alter @vt1r[pwl] = [ 0 1 1 1 ]
alter @vt1s[pwl] = [ 0 0 1 0 ]
alter @vt2r[pwl] = [ 0 1 1 1 ]
alter @vt2s[pwl] = [ 0 0 1 0 ]
alter @vw1[pwl] = [ 0 0 0.021 0 0.021001 1 ]
alter @vw2[pwl] = [ 0 1 0.02 1 0.020001 0 ]
tran 20u 0.12 0 5e-06
meas tran vam find v(aout) at=0.018
meas tran jb find v(jack) at=0.0199
meas tran jmax max v(jack) from=0.0199 to=0.12
meas tran jmin min v(jack) from=0.0199 to=0.12
let vamv = vam*1e3
let jbu = jb*1e6
let pa = abs(jmax - jb)
let pb = abs(jmin - jb)
let pku = pa*1e6
if pb > pa
  let pku = pb*1e6
end
echo "4,finale,-30,10,2,0,$&vamv,$&jbu,$&pku" >> /Users/roberto/EDA/.claude/worktrees/L48b/docs/preamp/data/2026-10-07/L48b/scatti/deck/scatti_v4.csv
destroy all
* ---- caso finale va=-30 g=10 ev=2 m=1
alter ca = 1p
alter rbya = 1m
alter ctx = 10u
alter rbyt = 1e12
alter cb = 1p
alter rbyb = 1m
alter rgate = 1Meg
alter rbal = 50k
alter vosa dc = 0.0233769
alter iosa dc = 2.33769e-08
alter rrgb = 0.1
alter rrg10b = 0.1
alter ra = 9553.32
alter rb = 91.8702
alter rc = 354.813
alter @vt1r[pwl] = [ 0 1 1 1 ]
alter @vt1s[pwl] = [ 0 0 1 0 ]
alter @vt2r[pwl] = [ 0 1 1 1 ]
alter @vt2s[pwl] = [ 0 0 1 0 ]
alter @vw1[pwl] = [ 0 0 0.02 0 0.020001 1 ]
alter @vw2[pwl] = [ 0 1 0.021 1 0.021001 0 ]
tran 20u 0.12 0 5e-06
meas tran vam find v(aout) at=0.018
meas tran jb find v(jack) at=0.0199
meas tran jmax max v(jack) from=0.0199 to=0.12
meas tran jmin min v(jack) from=0.0199 to=0.12
let vamv = vam*1e3
let jbu = jb*1e6
let pa = abs(jmax - jb)
let pb = abs(jmin - jb)
let pku = pa*1e6
if pb > pa
  let pku = pb*1e6
end
echo "4,finale,-30,10,2,1,$&vamv,$&jbu,$&pku" >> /Users/roberto/EDA/.claude/worktrees/L48b/docs/preamp/data/2026-10-07/L48b/scatti/deck/scatti_v4.csv
destroy all
* ---- caso finale va=-30 g=10 ev=3 m=0
alter ca = 1p
alter rbya = 1m
alter ctx = 10u
alter rbyt = 1e12
alter cb = 1p
alter rbyb = 1m
alter rgate = 1Meg
alter rbal = 50k
alter vosa dc = 0.0233769
alter iosa dc = 2.33769e-08
alter rrgb = 0.1
alter rrg10b = 0.1
alter ra = 0.001
alter rb = 2056.72
alter rc = 7943.28
alter @vt1r[pwl] = [ 0 1 0.02 1 0.020001 0 ]
alter @vt1s[pwl] = [ 0 0 0.021 0 0.021001 1 ]
alter @vt2r[pwl] = [ 0 1 1 1 ]
alter @vt2s[pwl] = [ 0 0 1 0 ]
alter @vw1[pwl] = [ 0 1 1 1 ]
alter @vw2[pwl] = [ 0 0 1 0 ]
tran 20u 0.12 0 5e-06
meas tran vam find v(aout) at=0.018
meas tran jb find v(jack) at=0.0199
meas tran jmax max v(jack) from=0.0199 to=0.12
meas tran jmin min v(jack) from=0.0199 to=0.12
let vamv = vam*1e3
let jbu = jb*1e6
let pa = abs(jmax - jb)
let pb = abs(jmin - jb)
let pku = pa*1e6
if pb > pa
  let pku = pb*1e6
end
echo "4,finale,-30,10,3,0,$&vamv,$&jbu,$&pku" >> /Users/roberto/EDA/.claude/worktrees/L48b/docs/preamp/data/2026-10-07/L48b/scatti/deck/scatti_v4.csv
destroy all
* ---- caso finale va=-30 g=10 ev=4 m=0
alter ca = 1p
alter rbya = 1m
alter ctx = 10u
alter rbyt = 1e12
alter cb = 1p
alter rbyb = 1m
alter rgate = 1Meg
alter rbal = 50k
alter vosa dc = 0.0233769
alter iosa dc = 2.33769e-08
alter rrgb = 0.1
alter rrg10b = 0.1
alter ra = 0.001
alter rb = 2056.72
alter rc = 7943.28
alter @vt1r[pwl] = [ 0 0 1 0 ]
alter @vt1s[pwl] = [ 0 1 1 1 ]
alter @vt2r[pwl] = [ 0 1 0.02 1 0.020001 0 ]
alter @vt2s[pwl] = [ 0 0 0.021 0 0.021001 1 ]
alter @vw1[pwl] = [ 0 1 1 1 ]
alter @vw2[pwl] = [ 0 0 1 0 ]
tran 20u 0.12 0 5e-06
meas tran vam find v(aout) at=0.018
meas tran jb find v(jack) at=0.0199
meas tran jmax max v(jack) from=0.0199 to=0.12
meas tran jmin min v(jack) from=0.0199 to=0.12
let vamv = vam*1e3
let jbu = jb*1e6
let pa = abs(jmax - jb)
let pb = abs(jmin - jb)
let pku = pa*1e6
if pb > pa
  let pku = pb*1e6
end
echo "4,finale,-30,10,4,0,$&vamv,$&jbu,$&pku" >> /Users/roberto/EDA/.claude/worktrees/L48b/docs/preamp/data/2026-10-07/L48b/scatti/deck/scatti_v4.csv
destroy all
* ---- caso finale va=30 g=0 ev=1 m=0
alter ca = 1p
alter rbya = 1m
alter ctx = 10u
alter rbyt = 1e12
alter cb = 1p
alter rbyb = 1m
alter rgate = 1Meg
alter rbal = 50k
alter vosa dc = -0.0366231
alter iosa dc = -3.66231e-08
alter rrgb = 1e+09
alter rrg10b = 1e+09
alter ra = 0.001
alter rb = 2056.72
alter rc = 7943.28
alter @vt1r[pwl] = [ 0 1 1 1 ]
alter @vt1s[pwl] = [ 0 0 1 0 ]
alter @vt2r[pwl] = [ 0 1 1 1 ]
alter @vt2s[pwl] = [ 0 0 1 0 ]
alter @vw1[pwl] = [ 0 1 0.02 1 0.020001 0 ]
alter @vw2[pwl] = [ 0 0 0.021 0 0.021001 1 ]
tran 20u 0.12 0 5e-06
meas tran vam find v(aout) at=0.018
meas tran jb find v(jack) at=0.0199
meas tran jmax max v(jack) from=0.0199 to=0.12
meas tran jmin min v(jack) from=0.0199 to=0.12
let vamv = vam*1e3
let jbu = jb*1e6
let pa = abs(jmax - jb)
let pb = abs(jmin - jb)
let pku = pa*1e6
if pb > pa
  let pku = pb*1e6
end
echo "4,finale,30,0,1,0,$&vamv,$&jbu,$&pku" >> /Users/roberto/EDA/.claude/worktrees/L48b/docs/preamp/data/2026-10-07/L48b/scatti/deck/scatti_v4.csv
destroy all
* ---- caso finale va=30 g=0 ev=1 m=1
alter ca = 1p
alter rbya = 1m
alter ctx = 10u
alter rbyt = 1e12
alter cb = 1p
alter rbyb = 1m
alter rgate = 1Meg
alter rbal = 50k
alter vosa dc = -0.0366231
alter iosa dc = -3.66231e-08
alter rrgb = 1e+09
alter rrg10b = 1e+09
alter ra = 0.001
alter rb = 2056.72
alter rc = 7943.28
alter @vt1r[pwl] = [ 0 1 1 1 ]
alter @vt1s[pwl] = [ 0 0 1 0 ]
alter @vt2r[pwl] = [ 0 1 1 1 ]
alter @vt2s[pwl] = [ 0 0 1 0 ]
alter @vw1[pwl] = [ 0 1 0.021 1 0.021001 0 ]
alter @vw2[pwl] = [ 0 0 0.02 0 0.020001 1 ]
tran 20u 0.12 0 5e-06
meas tran vam find v(aout) at=0.018
meas tran jb find v(jack) at=0.0199
meas tran jmax max v(jack) from=0.0199 to=0.12
meas tran jmin min v(jack) from=0.0199 to=0.12
let vamv = vam*1e3
let jbu = jb*1e6
let pa = abs(jmax - jb)
let pb = abs(jmin - jb)
let pku = pa*1e6
if pb > pa
  let pku = pb*1e6
end
echo "4,finale,30,0,1,1,$&vamv,$&jbu,$&pku" >> /Users/roberto/EDA/.claude/worktrees/L48b/docs/preamp/data/2026-10-07/L48b/scatti/deck/scatti_v4.csv
destroy all
* ---- caso finale va=30 g=0 ev=2 m=0
alter ca = 1p
alter rbya = 1m
alter ctx = 10u
alter rbyt = 1e12
alter cb = 1p
alter rbyb = 1m
alter rgate = 1Meg
alter rbal = 50k
alter vosa dc = -0.0366231
alter iosa dc = -3.66231e-08
alter rrgb = 1e+09
alter rrg10b = 1e+09
alter ra = 9553.32
alter rb = 91.8702
alter rc = 354.813
alter @vt1r[pwl] = [ 0 1 1 1 ]
alter @vt1s[pwl] = [ 0 0 1 0 ]
alter @vt2r[pwl] = [ 0 1 1 1 ]
alter @vt2s[pwl] = [ 0 0 1 0 ]
alter @vw1[pwl] = [ 0 0 0.021 0 0.021001 1 ]
alter @vw2[pwl] = [ 0 1 0.02 1 0.020001 0 ]
tran 20u 0.12 0 5e-06
meas tran vam find v(aout) at=0.018
meas tran jb find v(jack) at=0.0199
meas tran jmax max v(jack) from=0.0199 to=0.12
meas tran jmin min v(jack) from=0.0199 to=0.12
let vamv = vam*1e3
let jbu = jb*1e6
let pa = abs(jmax - jb)
let pb = abs(jmin - jb)
let pku = pa*1e6
if pb > pa
  let pku = pb*1e6
end
echo "4,finale,30,0,2,0,$&vamv,$&jbu,$&pku" >> /Users/roberto/EDA/.claude/worktrees/L48b/docs/preamp/data/2026-10-07/L48b/scatti/deck/scatti_v4.csv
destroy all
* ---- caso finale va=30 g=0 ev=2 m=1
alter ca = 1p
alter rbya = 1m
alter ctx = 10u
alter rbyt = 1e12
alter cb = 1p
alter rbyb = 1m
alter rgate = 1Meg
alter rbal = 50k
alter vosa dc = -0.0366231
alter iosa dc = -3.66231e-08
alter rrgb = 1e+09
alter rrg10b = 1e+09
alter ra = 9553.32
alter rb = 91.8702
alter rc = 354.813
alter @vt1r[pwl] = [ 0 1 1 1 ]
alter @vt1s[pwl] = [ 0 0 1 0 ]
alter @vt2r[pwl] = [ 0 1 1 1 ]
alter @vt2s[pwl] = [ 0 0 1 0 ]
alter @vw1[pwl] = [ 0 0 0.02 0 0.020001 1 ]
alter @vw2[pwl] = [ 0 1 0.021 1 0.021001 0 ]
tran 20u 0.12 0 5e-06
meas tran vam find v(aout) at=0.018
meas tran jb find v(jack) at=0.0199
meas tran jmax max v(jack) from=0.0199 to=0.12
meas tran jmin min v(jack) from=0.0199 to=0.12
let vamv = vam*1e3
let jbu = jb*1e6
let pa = abs(jmax - jb)
let pb = abs(jmin - jb)
let pku = pa*1e6
if pb > pa
  let pku = pb*1e6
end
echo "4,finale,30,0,2,1,$&vamv,$&jbu,$&pku" >> /Users/roberto/EDA/.claude/worktrees/L48b/docs/preamp/data/2026-10-07/L48b/scatti/deck/scatti_v4.csv
destroy all
* ---- caso finale va=30 g=0 ev=3 m=0
alter ca = 1p
alter rbya = 1m
alter ctx = 10u
alter rbyt = 1e12
alter cb = 1p
alter rbyb = 1m
alter rgate = 1Meg
alter rbal = 50k
alter vosa dc = -0.0366231
alter iosa dc = -3.66231e-08
alter rrgb = 1e+09
alter rrg10b = 1e+09
alter ra = 0.001
alter rb = 2056.72
alter rc = 7943.28
alter @vt1r[pwl] = [ 0 1 0.02 1 0.020001 0 ]
alter @vt1s[pwl] = [ 0 0 0.021 0 0.021001 1 ]
alter @vt2r[pwl] = [ 0 1 1 1 ]
alter @vt2s[pwl] = [ 0 0 1 0 ]
alter @vw1[pwl] = [ 0 1 1 1 ]
alter @vw2[pwl] = [ 0 0 1 0 ]
tran 20u 0.12 0 5e-06
meas tran vam find v(aout) at=0.018
meas tran jb find v(jack) at=0.0199
meas tran jmax max v(jack) from=0.0199 to=0.12
meas tran jmin min v(jack) from=0.0199 to=0.12
let vamv = vam*1e3
let jbu = jb*1e6
let pa = abs(jmax - jb)
let pb = abs(jmin - jb)
let pku = pa*1e6
if pb > pa
  let pku = pb*1e6
end
echo "4,finale,30,0,3,0,$&vamv,$&jbu,$&pku" >> /Users/roberto/EDA/.claude/worktrees/L48b/docs/preamp/data/2026-10-07/L48b/scatti/deck/scatti_v4.csv
destroy all
* ---- caso finale va=30 g=0 ev=4 m=0
alter ca = 1p
alter rbya = 1m
alter ctx = 10u
alter rbyt = 1e12
alter cb = 1p
alter rbyb = 1m
alter rgate = 1Meg
alter rbal = 50k
alter vosa dc = -0.0366231
alter iosa dc = -3.66231e-08
alter rrgb = 1e+09
alter rrg10b = 1e+09
alter ra = 0.001
alter rb = 2056.72
alter rc = 7943.28
alter @vt1r[pwl] = [ 0 0 1 0 ]
alter @vt1s[pwl] = [ 0 1 1 1 ]
alter @vt2r[pwl] = [ 0 1 0.02 1 0.020001 0 ]
alter @vt2s[pwl] = [ 0 0 0.021 0 0.021001 1 ]
alter @vw1[pwl] = [ 0 1 1 1 ]
alter @vw2[pwl] = [ 0 0 1 0 ]
tran 20u 0.12 0 5e-06
meas tran vam find v(aout) at=0.018
meas tran jb find v(jack) at=0.0199
meas tran jmax max v(jack) from=0.0199 to=0.12
meas tran jmin min v(jack) from=0.0199 to=0.12
let vamv = vam*1e3
let jbu = jb*1e6
let pa = abs(jmax - jb)
let pb = abs(jmin - jb)
let pku = pa*1e6
if pb > pa
  let pku = pb*1e6
end
echo "4,finale,30,0,4,0,$&vamv,$&jbu,$&pku" >> /Users/roberto/EDA/.claude/worktrees/L48b/docs/preamp/data/2026-10-07/L48b/scatti/deck/scatti_v4.csv
destroy all
* ---- caso finale va=30 g=3 ev=1 m=0
alter ca = 1p
alter rbya = 1m
alter ctx = 10u
alter rbyt = 1e12
alter cb = 1p
alter rbyb = 1m
alter rgate = 1Meg
alter rbal = 50k
alter vosa dc = -0.0366231
alter iosa dc = -3.66231e-08
alter rrgb = 0.1
alter rrg10b = 1e+09
alter ra = 0.001
alter rb = 2056.72
alter rc = 7943.28
alter @vt1r[pwl] = [ 0 1 1 1 ]
alter @vt1s[pwl] = [ 0 0 1 0 ]
alter @vt2r[pwl] = [ 0 1 1 1 ]
alter @vt2s[pwl] = [ 0 0 1 0 ]
alter @vw1[pwl] = [ 0 1 0.02 1 0.020001 0 ]
alter @vw2[pwl] = [ 0 0 0.021 0 0.021001 1 ]
tran 20u 0.12 0 5e-06
meas tran vam find v(aout) at=0.018
meas tran jb find v(jack) at=0.0199
meas tran jmax max v(jack) from=0.0199 to=0.12
meas tran jmin min v(jack) from=0.0199 to=0.12
let vamv = vam*1e3
let jbu = jb*1e6
let pa = abs(jmax - jb)
let pb = abs(jmin - jb)
let pku = pa*1e6
if pb > pa
  let pku = pb*1e6
end
echo "4,finale,30,3,1,0,$&vamv,$&jbu,$&pku" >> /Users/roberto/EDA/.claude/worktrees/L48b/docs/preamp/data/2026-10-07/L48b/scatti/deck/scatti_v4.csv
destroy all
* ---- caso finale va=30 g=3 ev=1 m=1
alter ca = 1p
alter rbya = 1m
alter ctx = 10u
alter rbyt = 1e12
alter cb = 1p
alter rbyb = 1m
alter rgate = 1Meg
alter rbal = 50k
alter vosa dc = -0.0366231
alter iosa dc = -3.66231e-08
alter rrgb = 0.1
alter rrg10b = 1e+09
alter ra = 0.001
alter rb = 2056.72
alter rc = 7943.28
alter @vt1r[pwl] = [ 0 1 1 1 ]
alter @vt1s[pwl] = [ 0 0 1 0 ]
alter @vt2r[pwl] = [ 0 1 1 1 ]
alter @vt2s[pwl] = [ 0 0 1 0 ]
alter @vw1[pwl] = [ 0 1 0.021 1 0.021001 0 ]
alter @vw2[pwl] = [ 0 0 0.02 0 0.020001 1 ]
tran 20u 0.12 0 5e-06
meas tran vam find v(aout) at=0.018
meas tran jb find v(jack) at=0.0199
meas tran jmax max v(jack) from=0.0199 to=0.12
meas tran jmin min v(jack) from=0.0199 to=0.12
let vamv = vam*1e3
let jbu = jb*1e6
let pa = abs(jmax - jb)
let pb = abs(jmin - jb)
let pku = pa*1e6
if pb > pa
  let pku = pb*1e6
end
echo "4,finale,30,3,1,1,$&vamv,$&jbu,$&pku" >> /Users/roberto/EDA/.claude/worktrees/L48b/docs/preamp/data/2026-10-07/L48b/scatti/deck/scatti_v4.csv
destroy all
* ---- caso finale va=30 g=3 ev=2 m=0
alter ca = 1p
alter rbya = 1m
alter ctx = 10u
alter rbyt = 1e12
alter cb = 1p
alter rbyb = 1m
alter rgate = 1Meg
alter rbal = 50k
alter vosa dc = -0.0366231
alter iosa dc = -3.66231e-08
alter rrgb = 0.1
alter rrg10b = 1e+09
alter ra = 9553.32
alter rb = 91.8702
alter rc = 354.813
alter @vt1r[pwl] = [ 0 1 1 1 ]
alter @vt1s[pwl] = [ 0 0 1 0 ]
alter @vt2r[pwl] = [ 0 1 1 1 ]
alter @vt2s[pwl] = [ 0 0 1 0 ]
alter @vw1[pwl] = [ 0 0 0.021 0 0.021001 1 ]
alter @vw2[pwl] = [ 0 1 0.02 1 0.020001 0 ]
tran 20u 0.12 0 5e-06
meas tran vam find v(aout) at=0.018
meas tran jb find v(jack) at=0.0199
meas tran jmax max v(jack) from=0.0199 to=0.12
meas tran jmin min v(jack) from=0.0199 to=0.12
let vamv = vam*1e3
let jbu = jb*1e6
let pa = abs(jmax - jb)
let pb = abs(jmin - jb)
let pku = pa*1e6
if pb > pa
  let pku = pb*1e6
end
echo "4,finale,30,3,2,0,$&vamv,$&jbu,$&pku" >> /Users/roberto/EDA/.claude/worktrees/L48b/docs/preamp/data/2026-10-07/L48b/scatti/deck/scatti_v4.csv
destroy all
* ---- caso finale va=30 g=3 ev=2 m=1
alter ca = 1p
alter rbya = 1m
alter ctx = 10u
alter rbyt = 1e12
alter cb = 1p
alter rbyb = 1m
alter rgate = 1Meg
alter rbal = 50k
alter vosa dc = -0.0366231
alter iosa dc = -3.66231e-08
alter rrgb = 0.1
alter rrg10b = 1e+09
alter ra = 9553.32
alter rb = 91.8702
alter rc = 354.813
alter @vt1r[pwl] = [ 0 1 1 1 ]
alter @vt1s[pwl] = [ 0 0 1 0 ]
alter @vt2r[pwl] = [ 0 1 1 1 ]
alter @vt2s[pwl] = [ 0 0 1 0 ]
alter @vw1[pwl] = [ 0 0 0.02 0 0.020001 1 ]
alter @vw2[pwl] = [ 0 1 0.021 1 0.021001 0 ]
tran 20u 0.12 0 5e-06
meas tran vam find v(aout) at=0.018
meas tran jb find v(jack) at=0.0199
meas tran jmax max v(jack) from=0.0199 to=0.12
meas tran jmin min v(jack) from=0.0199 to=0.12
let vamv = vam*1e3
let jbu = jb*1e6
let pa = abs(jmax - jb)
let pb = abs(jmin - jb)
let pku = pa*1e6
if pb > pa
  let pku = pb*1e6
end
echo "4,finale,30,3,2,1,$&vamv,$&jbu,$&pku" >> /Users/roberto/EDA/.claude/worktrees/L48b/docs/preamp/data/2026-10-07/L48b/scatti/deck/scatti_v4.csv
destroy all
* ---- caso finale va=30 g=3 ev=3 m=0
alter ca = 1p
alter rbya = 1m
alter ctx = 10u
alter rbyt = 1e12
alter cb = 1p
alter rbyb = 1m
alter rgate = 1Meg
alter rbal = 50k
alter vosa dc = -0.0366231
alter iosa dc = -3.66231e-08
alter rrgb = 0.1
alter rrg10b = 1e+09
alter ra = 0.001
alter rb = 2056.72
alter rc = 7943.28
alter @vt1r[pwl] = [ 0 1 0.02 1 0.020001 0 ]
alter @vt1s[pwl] = [ 0 0 0.021 0 0.021001 1 ]
alter @vt2r[pwl] = [ 0 1 1 1 ]
alter @vt2s[pwl] = [ 0 0 1 0 ]
alter @vw1[pwl] = [ 0 1 1 1 ]
alter @vw2[pwl] = [ 0 0 1 0 ]
tran 20u 0.12 0 5e-06
meas tran vam find v(aout) at=0.018
meas tran jb find v(jack) at=0.0199
meas tran jmax max v(jack) from=0.0199 to=0.12
meas tran jmin min v(jack) from=0.0199 to=0.12
let vamv = vam*1e3
let jbu = jb*1e6
let pa = abs(jmax - jb)
let pb = abs(jmin - jb)
let pku = pa*1e6
if pb > pa
  let pku = pb*1e6
end
echo "4,finale,30,3,3,0,$&vamv,$&jbu,$&pku" >> /Users/roberto/EDA/.claude/worktrees/L48b/docs/preamp/data/2026-10-07/L48b/scatti/deck/scatti_v4.csv
destroy all
* ---- caso finale va=30 g=3 ev=4 m=0
alter ca = 1p
alter rbya = 1m
alter ctx = 10u
alter rbyt = 1e12
alter cb = 1p
alter rbyb = 1m
alter rgate = 1Meg
alter rbal = 50k
alter vosa dc = -0.0366231
alter iosa dc = -3.66231e-08
alter rrgb = 0.1
alter rrg10b = 1e+09
alter ra = 0.001
alter rb = 2056.72
alter rc = 7943.28
alter @vt1r[pwl] = [ 0 0 1 0 ]
alter @vt1s[pwl] = [ 0 1 1 1 ]
alter @vt2r[pwl] = [ 0 1 0.02 1 0.020001 0 ]
alter @vt2s[pwl] = [ 0 0 0.021 0 0.021001 1 ]
alter @vw1[pwl] = [ 0 1 1 1 ]
alter @vw2[pwl] = [ 0 0 1 0 ]
tran 20u 0.12 0 5e-06
meas tran vam find v(aout) at=0.018
meas tran jb find v(jack) at=0.0199
meas tran jmax max v(jack) from=0.0199 to=0.12
meas tran jmin min v(jack) from=0.0199 to=0.12
let vamv = vam*1e3
let jbu = jb*1e6
let pa = abs(jmax - jb)
let pb = abs(jmin - jb)
let pku = pa*1e6
if pb > pa
  let pku = pb*1e6
end
echo "4,finale,30,3,4,0,$&vamv,$&jbu,$&pku" >> /Users/roberto/EDA/.claude/worktrees/L48b/docs/preamp/data/2026-10-07/L48b/scatti/deck/scatti_v4.csv
destroy all
* ---- caso finale va=30 g=10 ev=1 m=0
alter ca = 1p
alter rbya = 1m
alter ctx = 10u
alter rbyt = 1e12
alter cb = 1p
alter rbyb = 1m
alter rgate = 1Meg
alter rbal = 50k
alter vosa dc = -0.0366231
alter iosa dc = -3.66231e-08
alter rrgb = 0.1
alter rrg10b = 0.1
alter ra = 0.001
alter rb = 2056.72
alter rc = 7943.28
alter @vt1r[pwl] = [ 0 1 1 1 ]
alter @vt1s[pwl] = [ 0 0 1 0 ]
alter @vt2r[pwl] = [ 0 1 1 1 ]
alter @vt2s[pwl] = [ 0 0 1 0 ]
alter @vw1[pwl] = [ 0 1 0.02 1 0.020001 0 ]
alter @vw2[pwl] = [ 0 0 0.021 0 0.021001 1 ]
tran 20u 0.12 0 5e-06
meas tran vam find v(aout) at=0.018
meas tran jb find v(jack) at=0.0199
meas tran jmax max v(jack) from=0.0199 to=0.12
meas tran jmin min v(jack) from=0.0199 to=0.12
let vamv = vam*1e3
let jbu = jb*1e6
let pa = abs(jmax - jb)
let pb = abs(jmin - jb)
let pku = pa*1e6
if pb > pa
  let pku = pb*1e6
end
echo "4,finale,30,10,1,0,$&vamv,$&jbu,$&pku" >> /Users/roberto/EDA/.claude/worktrees/L48b/docs/preamp/data/2026-10-07/L48b/scatti/deck/scatti_v4.csv
destroy all
* ---- caso finale va=30 g=10 ev=1 m=1
alter ca = 1p
alter rbya = 1m
alter ctx = 10u
alter rbyt = 1e12
alter cb = 1p
alter rbyb = 1m
alter rgate = 1Meg
alter rbal = 50k
alter vosa dc = -0.0366231
alter iosa dc = -3.66231e-08
alter rrgb = 0.1
alter rrg10b = 0.1
alter ra = 0.001
alter rb = 2056.72
alter rc = 7943.28
alter @vt1r[pwl] = [ 0 1 1 1 ]
alter @vt1s[pwl] = [ 0 0 1 0 ]
alter @vt2r[pwl] = [ 0 1 1 1 ]
alter @vt2s[pwl] = [ 0 0 1 0 ]
alter @vw1[pwl] = [ 0 1 0.021 1 0.021001 0 ]
alter @vw2[pwl] = [ 0 0 0.02 0 0.020001 1 ]
tran 20u 0.12 0 5e-06
meas tran vam find v(aout) at=0.018
meas tran jb find v(jack) at=0.0199
meas tran jmax max v(jack) from=0.0199 to=0.12
meas tran jmin min v(jack) from=0.0199 to=0.12
let vamv = vam*1e3
let jbu = jb*1e6
let pa = abs(jmax - jb)
let pb = abs(jmin - jb)
let pku = pa*1e6
if pb > pa
  let pku = pb*1e6
end
echo "4,finale,30,10,1,1,$&vamv,$&jbu,$&pku" >> /Users/roberto/EDA/.claude/worktrees/L48b/docs/preamp/data/2026-10-07/L48b/scatti/deck/scatti_v4.csv
destroy all
* ---- caso finale va=30 g=10 ev=2 m=0
alter ca = 1p
alter rbya = 1m
alter ctx = 10u
alter rbyt = 1e12
alter cb = 1p
alter rbyb = 1m
alter rgate = 1Meg
alter rbal = 50k
alter vosa dc = -0.0366231
alter iosa dc = -3.66231e-08
alter rrgb = 0.1
alter rrg10b = 0.1
alter ra = 9553.32
alter rb = 91.8702
alter rc = 354.813
alter @vt1r[pwl] = [ 0 1 1 1 ]
alter @vt1s[pwl] = [ 0 0 1 0 ]
alter @vt2r[pwl] = [ 0 1 1 1 ]
alter @vt2s[pwl] = [ 0 0 1 0 ]
alter @vw1[pwl] = [ 0 0 0.021 0 0.021001 1 ]
alter @vw2[pwl] = [ 0 1 0.02 1 0.020001 0 ]
tran 20u 0.12 0 5e-06
meas tran vam find v(aout) at=0.018
meas tran jb find v(jack) at=0.0199
meas tran jmax max v(jack) from=0.0199 to=0.12
meas tran jmin min v(jack) from=0.0199 to=0.12
let vamv = vam*1e3
let jbu = jb*1e6
let pa = abs(jmax - jb)
let pb = abs(jmin - jb)
let pku = pa*1e6
if pb > pa
  let pku = pb*1e6
end
echo "4,finale,30,10,2,0,$&vamv,$&jbu,$&pku" >> /Users/roberto/EDA/.claude/worktrees/L48b/docs/preamp/data/2026-10-07/L48b/scatti/deck/scatti_v4.csv
destroy all
* ---- caso finale va=30 g=10 ev=2 m=1
alter ca = 1p
alter rbya = 1m
alter ctx = 10u
alter rbyt = 1e12
alter cb = 1p
alter rbyb = 1m
alter rgate = 1Meg
alter rbal = 50k
alter vosa dc = -0.0366231
alter iosa dc = -3.66231e-08
alter rrgb = 0.1
alter rrg10b = 0.1
alter ra = 9553.32
alter rb = 91.8702
alter rc = 354.813
alter @vt1r[pwl] = [ 0 1 1 1 ]
alter @vt1s[pwl] = [ 0 0 1 0 ]
alter @vt2r[pwl] = [ 0 1 1 1 ]
alter @vt2s[pwl] = [ 0 0 1 0 ]
alter @vw1[pwl] = [ 0 0 0.02 0 0.020001 1 ]
alter @vw2[pwl] = [ 0 1 0.021 1 0.021001 0 ]
tran 20u 0.12 0 5e-06
meas tran vam find v(aout) at=0.018
meas tran jb find v(jack) at=0.0199
meas tran jmax max v(jack) from=0.0199 to=0.12
meas tran jmin min v(jack) from=0.0199 to=0.12
let vamv = vam*1e3
let jbu = jb*1e6
let pa = abs(jmax - jb)
let pb = abs(jmin - jb)
let pku = pa*1e6
if pb > pa
  let pku = pb*1e6
end
echo "4,finale,30,10,2,1,$&vamv,$&jbu,$&pku" >> /Users/roberto/EDA/.claude/worktrees/L48b/docs/preamp/data/2026-10-07/L48b/scatti/deck/scatti_v4.csv
destroy all
* ---- caso finale va=30 g=10 ev=3 m=0
alter ca = 1p
alter rbya = 1m
alter ctx = 10u
alter rbyt = 1e12
alter cb = 1p
alter rbyb = 1m
alter rgate = 1Meg
alter rbal = 50k
alter vosa dc = -0.0366231
alter iosa dc = -3.66231e-08
alter rrgb = 0.1
alter rrg10b = 0.1
alter ra = 0.001
alter rb = 2056.72
alter rc = 7943.28
alter @vt1r[pwl] = [ 0 1 0.02 1 0.020001 0 ]
alter @vt1s[pwl] = [ 0 0 0.021 0 0.021001 1 ]
alter @vt2r[pwl] = [ 0 1 1 1 ]
alter @vt2s[pwl] = [ 0 0 1 0 ]
alter @vw1[pwl] = [ 0 1 1 1 ]
alter @vw2[pwl] = [ 0 0 1 0 ]
tran 20u 0.12 0 5e-06
meas tran vam find v(aout) at=0.018
meas tran jb find v(jack) at=0.0199
meas tran jmax max v(jack) from=0.0199 to=0.12
meas tran jmin min v(jack) from=0.0199 to=0.12
let vamv = vam*1e3
let jbu = jb*1e6
let pa = abs(jmax - jb)
let pb = abs(jmin - jb)
let pku = pa*1e6
if pb > pa
  let pku = pb*1e6
end
echo "4,finale,30,10,3,0,$&vamv,$&jbu,$&pku" >> /Users/roberto/EDA/.claude/worktrees/L48b/docs/preamp/data/2026-10-07/L48b/scatti/deck/scatti_v4.csv
destroy all
* ---- caso finale va=30 g=10 ev=4 m=0
alter ca = 1p
alter rbya = 1m
alter ctx = 10u
alter rbyt = 1e12
alter cb = 1p
alter rbyb = 1m
alter rgate = 1Meg
alter rbal = 50k
alter vosa dc = -0.0366231
alter iosa dc = -3.66231e-08
alter rrgb = 0.1
alter rrg10b = 0.1
alter ra = 0.001
alter rb = 2056.72
alter rc = 7943.28
alter @vt1r[pwl] = [ 0 0 1 0 ]
alter @vt1s[pwl] = [ 0 1 1 1 ]
alter @vt2r[pwl] = [ 0 1 0.02 1 0.020001 0 ]
alter @vt2s[pwl] = [ 0 0 0.021 0 0.021001 1 ]
alter @vw1[pwl] = [ 0 1 1 1 ]
alter @vw2[pwl] = [ 0 0 1 0 ]
tran 20u 0.12 0 5e-06
meas tran vam find v(aout) at=0.018
meas tran jb find v(jack) at=0.0199
meas tran jmax max v(jack) from=0.0199 to=0.12
meas tran jmin min v(jack) from=0.0199 to=0.12
let vamv = vam*1e3
let jbu = jb*1e6
let pa = abs(jmax - jb)
let pb = abs(jmin - jb)
let pku = pa*1e6
if pb > pa
  let pku = pb*1e6
end
echo "4,finale,30,10,4,0,$&vamv,$&jbu,$&pku" >> /Users/roberto/EDA/.claude/worktrees/L48b/docs/preamp/data/2026-10-07/L48b/scatti/deck/scatti_v4.csv
destroy all
quit
.endc

.end
