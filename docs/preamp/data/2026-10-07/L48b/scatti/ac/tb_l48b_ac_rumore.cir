tb_l48b_scatti - L48b variante ac: il gradino al jack a uno scatto del volume o del trim
* GENERATO da docs/preamp/data/2026-10-07/L48b/scatti/genera_scatti.py - non modificare a mano.
* Prima riga = titolo (limitations #10).
.include /Users/roberto/EDA/.claude/worktrees/L48b/models/jfet/lsk489.lib
.include /Users/roberto/EDA/.claude/worktrees/L48b/models/bjt_npn/mmbt5551.lib
.include /Users/roberto/EDA/.claude/worktrees/L48b/models/bjt_pnp/mmbt5401.lib
.include /Users/roberto/EDA/.claude/worktrees/L48b/models/bjt_npn/mje15032.lib
.include /Users/roberto/EDA/.claude/worktrees/L48b/models/bjt_pnp/mje15033.lib
.include /Users/roberto/EDA/.claude/worktrees/L48b/models/diodes/1n4148.lib
.include /Users/roberto/EDA/.claude/worktrees/L48b/models/bjt_pnp/ls350.lib
.include /Users/roberto/EDA/.claude/worktrees/L48b/spice/preamp/gain_block.subckt
* il blocco B vero non ha R113 (r_in=None, preamp_audio.py): la copia senza, scritta da
* genera_scatti.py dal file generato (col cursore aperto, m0, R113 deciderebbe il gate)
.include /Users/roberto/EDA/.claude/worktrees/L48b/docs/preamp/data/2026-10-07/L48b/scatti/ac/gain_block_b_senza_r113.subckt

VPP VPLUS 0 DC 15
VMM VMINUS 0 DC -15

* --- la sorgente scelta e la rete d'ingresso di ADR-064 (tb_trim.cir) ---
VSRC  VSN 0 DC 0 AC 1
RSRC  VSN JIN 1.5
RJ    JIN 0 10Meg
CIN   JIN SEL 1u
RSEL  SEL 0 470k
RKSEL SEL SELK 0.1
* la continua del blocco A (limitations #44: IOSA da' a R113 la corrente di VOSA)
VOSA  SELK AIN DC 0
IOSA  AIN 0 DC 0

XA AIN AOUT AFB ARG ARG10 VPLUS VMINUS GAINBLOCK
RARG   ARG   0 1G
RARG10 ARG10 0 1G

* --- v2: il condensatore all'uscita del blocco A, prima del trim (RBYA = 1m: assente) ---
CA   AOUT AOC 1p
RBYA AOUT AOC 1m

* --- la scala del trim, cand 2 di trim.py ---
RL1 AOC TAP6 845
RL2 TAP6 TAP12 464
RL3 TAP12 0 464

.model SWK SW(RON=0.1 ROFF=1e12 VT=0.5 VH=0.25)
* --- i contatti del trim, che si muovono nel tempo; 15 pF ciascuno ---
RST1R AOC ATOP 0.1
CT1R AOC ATOP 15p
RST1S T2C ATOP 1G
CT1S T2C ATOP 15p
RST2R TAP6 T2C 0.1
CT2R TAP6 T2C 15p
RST2S TAP12 T2C 1G
CT2S TAP12 T2C 15p
VT1R NT1R 0 PWL(0 1 1 1)
VT1S NT1S 0 PWL(0 0 1 0)
VT2R NT2R 0 PWL(0 1 1 1)
VT2S NT2S 0 PWL(0 0 1 0)

* --- v3: il condensatore fra il trim e l'attenuatore (RBYT = 1m: assente) ---
CTX  ATOP ATT 1p
RBYT ATOP ATT 1m
* il cablaggio verso l'attenuatore a pannello
CWIRE ATT 0 100p
* v4: il bilanciamento MN 50k allo scatto centrale (ADR-065), la pista dalla cima a massa
RBAL ATT 0 1e12

* --- l'attenuatore a scatti da 10 k, scala in serie, e il cursore ---
RA ATT T1 1m
RB T1 T2 2.057k
RC T2 0 7.943k
RSW1 T1 WIP 0.1
RSW2 T2 WIP 1G
VW1 NW1 0 PWL(0 1 1 1)
VW2 NW2 0 PWL(0 0 1 0)
* il cavo del cursore dal pannello alla scheda: la stessa ipotesi del cablaggio della cima
* (100 pF). Senza, col cursore aperto (m0) il gate del blocco B non ha nessuna capacita' verso
* massa e il simulatore lo porta a 0 V in < 30 us: un artefatto del banco (sonda L48b).
CWIP WIP 0 100p

* --- v1: il condensatore all'ingresso del blocco B, con la sua resistenza di gate ---
CB    WIP BIN 1p
RBYB  WIP BIN 1m
RGATE BIN 0 1e12

* --- il blocco B, 0 / +3 / +10 dB ---
XB BIN BOUT BFB BRG BRG10 VPLUS VMINUS GAINBLOCKB
CSTB    BRG   0 15p
RRGB    BRG   0 1G
CSTB10  BRG10 0 15p
RRG10B  BRG10 0 1G

RISO   BOUT BOUTA 47
COUT   BOUTA JACK 4.7u
RBLEED JACK 0 220k
RLOAD  JACK 0 100k

.control
set noaskquit
option itl1=1000 gmin=1e-15
echo "var,cap,guad_db,att,carico_o_rsrc,grandezza,valore" > /Users/roberto/EDA/.claude/worktrees/L48b/docs/preamp/data/2026-10-07/L48b/scatti/ac/ac_rumore.csv
* ---- ac oggi g=0 att=1
alter ca = 1p
alter rbya = 1m
alter ctx = 1p
alter rbyt = 1m
alter cb = 1p
alter rbyb = 1m
alter rgate = 1e12
alter rbal = 1e12
alter vosa dc = 0
alter iosa dc = 0
alter rrgb = 1e+09
alter rrg10b = 1e+09
alter ra = 0.001
alter rb = 2057
alter rc = 7943
alter @vt1r[pwl] = [ 0 1 1 1 ]
alter @vt1s[pwl] = [ 0 0 1 0 ]
alter @vt2r[pwl] = [ 0 1 1 1 ]
alter @vt2s[pwl] = [ 0 0 1 0 ]
alter @vw1[pwl] = [ 0 1 1 1 ]
alter @vw2[pwl] = [ 0 0 1 0 ]
alter rload = 100k
alter rsrc = 1.5
ac dec 50 10 20k
let rdb = vdb(jack)
meas ac r20 find rdb at=20
meas ac r1k find rdb at=1000
let e9 = r20 - r1k
echo "0,oggi,0,1,100k,e9_db,$&e9" >> /Users/roberto/EDA/.claude/worktrees/L48b/docs/preamp/data/2026-10-07/L48b/scatti/ac/ac_rumore.csv
destroy all
alter rload = 10k
alter rsrc = 1.5
ac dec 50 10 20k
let rdb = vdb(jack)
meas ac r20 find rdb at=20
meas ac r1k find rdb at=1000
let e9 = r20 - r1k
echo "0,oggi,0,1,10k,e9_db,$&e9" >> /Users/roberto/EDA/.claude/worktrees/L48b/docs/preamp/data/2026-10-07/L48b/scatti/ac/ac_rumore.csv
destroy all
alter rload = 100k
alter rsrc = 1.5
noise v(jack) vsrc dec 50 20 20000 1
setplot noise2
let onu = onoise_total*1e6
echo "0,oggi,0,1,1.5,e5_uv,$&onu" >> /Users/roberto/EDA/.claude/worktrees/L48b/docs/preamp/data/2026-10-07/L48b/scatti/ac/ac_rumore.csv
destroy all
alter rsrc = 430
noise v(jack) vsrc dec 50 20 20000 1
setplot noise2
let onu = onoise_total*1e6
echo "0,oggi,0,1,430,e5_uv,$&onu" >> /Users/roberto/EDA/.claude/worktrees/L48b/docs/preamp/data/2026-10-07/L48b/scatti/ac/ac_rumore.csv
destroy all
alter rsrc = 1.5
* ---- ac oggi g=0 att=2
alter ca = 1p
alter rbya = 1m
alter ctx = 1p
alter rbyt = 1m
alter cb = 1p
alter rbyb = 1m
alter rgate = 1e12
alter rbal = 1e12
alter vosa dc = 0
alter iosa dc = 0
alter rrgb = 1e+09
alter rrg10b = 1e+09
alter ra = 5000
alter rb = 0.001
alter rc = 5000
alter @vt1r[pwl] = [ 0 1 1 1 ]
alter @vt1s[pwl] = [ 0 0 1 0 ]
alter @vt2r[pwl] = [ 0 1 1 1 ]
alter @vt2s[pwl] = [ 0 0 1 0 ]
alter @vw1[pwl] = [ 0 1 1 1 ]
alter @vw2[pwl] = [ 0 0 1 0 ]
alter rload = 100k
alter rsrc = 1.5
ac dec 50 10 20k
let rdb = vdb(jack)
meas ac r20 find rdb at=20
meas ac r1k find rdb at=1000
let e9 = r20 - r1k
echo "0,oggi,0,2,100k,e9_db,$&e9" >> /Users/roberto/EDA/.claude/worktrees/L48b/docs/preamp/data/2026-10-07/L48b/scatti/ac/ac_rumore.csv
destroy all
alter rload = 10k
alter rsrc = 1.5
ac dec 50 10 20k
let rdb = vdb(jack)
meas ac r20 find rdb at=20
meas ac r1k find rdb at=1000
let e9 = r20 - r1k
echo "0,oggi,0,2,10k,e9_db,$&e9" >> /Users/roberto/EDA/.claude/worktrees/L48b/docs/preamp/data/2026-10-07/L48b/scatti/ac/ac_rumore.csv
destroy all
alter rload = 100k
alter rsrc = 1.5
noise v(jack) vsrc dec 50 20 20000 1
setplot noise2
let onu = onoise_total*1e6
echo "0,oggi,0,2,1.5,e5_uv,$&onu" >> /Users/roberto/EDA/.claude/worktrees/L48b/docs/preamp/data/2026-10-07/L48b/scatti/ac/ac_rumore.csv
destroy all
alter rsrc = 430
noise v(jack) vsrc dec 50 20 20000 1
setplot noise2
let onu = onoise_total*1e6
echo "0,oggi,0,2,430,e5_uv,$&onu" >> /Users/roberto/EDA/.claude/worktrees/L48b/docs/preamp/data/2026-10-07/L48b/scatti/ac/ac_rumore.csv
destroy all
alter rsrc = 1.5
* ---- ac oggi g=10 att=1
alter ca = 1p
alter rbya = 1m
alter ctx = 1p
alter rbyt = 1m
alter cb = 1p
alter rbyb = 1m
alter rgate = 1e12
alter rbal = 1e12
alter vosa dc = 0
alter iosa dc = 0
alter rrgb = 0.1
alter rrg10b = 0.1
alter ra = 0.001
alter rb = 2057
alter rc = 7943
alter @vt1r[pwl] = [ 0 1 1 1 ]
alter @vt1s[pwl] = [ 0 0 1 0 ]
alter @vt2r[pwl] = [ 0 1 1 1 ]
alter @vt2s[pwl] = [ 0 0 1 0 ]
alter @vw1[pwl] = [ 0 1 1 1 ]
alter @vw2[pwl] = [ 0 0 1 0 ]
alter rload = 100k
alter rsrc = 1.5
ac dec 50 10 20k
let rdb = vdb(jack)
meas ac r20 find rdb at=20
meas ac r1k find rdb at=1000
let e9 = r20 - r1k
echo "0,oggi,10,1,100k,e9_db,$&e9" >> /Users/roberto/EDA/.claude/worktrees/L48b/docs/preamp/data/2026-10-07/L48b/scatti/ac/ac_rumore.csv
destroy all
alter rload = 10k
alter rsrc = 1.5
ac dec 50 10 20k
let rdb = vdb(jack)
meas ac r20 find rdb at=20
meas ac r1k find rdb at=1000
let e9 = r20 - r1k
echo "0,oggi,10,1,10k,e9_db,$&e9" >> /Users/roberto/EDA/.claude/worktrees/L48b/docs/preamp/data/2026-10-07/L48b/scatti/ac/ac_rumore.csv
destroy all
alter rload = 100k
alter rsrc = 1.5
noise v(jack) vsrc dec 50 20 20000 1
setplot noise2
let onu = onoise_total*1e6
echo "0,oggi,10,1,1.5,e5_uv,$&onu" >> /Users/roberto/EDA/.claude/worktrees/L48b/docs/preamp/data/2026-10-07/L48b/scatti/ac/ac_rumore.csv
destroy all
alter rsrc = 430
noise v(jack) vsrc dec 50 20 20000 1
setplot noise2
let onu = onoise_total*1e6
echo "0,oggi,10,1,430,e5_uv,$&onu" >> /Users/roberto/EDA/.claude/worktrees/L48b/docs/preamp/data/2026-10-07/L48b/scatti/ac/ac_rumore.csv
destroy all
alter rsrc = 1.5
* ---- ac oggi g=10 att=2
alter ca = 1p
alter rbya = 1m
alter ctx = 1p
alter rbyt = 1m
alter cb = 1p
alter rbyb = 1m
alter rgate = 1e12
alter rbal = 1e12
alter vosa dc = 0
alter iosa dc = 0
alter rrgb = 0.1
alter rrg10b = 0.1
alter ra = 5000
alter rb = 0.001
alter rc = 5000
alter @vt1r[pwl] = [ 0 1 1 1 ]
alter @vt1s[pwl] = [ 0 0 1 0 ]
alter @vt2r[pwl] = [ 0 1 1 1 ]
alter @vt2s[pwl] = [ 0 0 1 0 ]
alter @vw1[pwl] = [ 0 1 1 1 ]
alter @vw2[pwl] = [ 0 0 1 0 ]
alter rload = 100k
alter rsrc = 1.5
ac dec 50 10 20k
let rdb = vdb(jack)
meas ac r20 find rdb at=20
meas ac r1k find rdb at=1000
let e9 = r20 - r1k
echo "0,oggi,10,2,100k,e9_db,$&e9" >> /Users/roberto/EDA/.claude/worktrees/L48b/docs/preamp/data/2026-10-07/L48b/scatti/ac/ac_rumore.csv
destroy all
alter rload = 10k
alter rsrc = 1.5
ac dec 50 10 20k
let rdb = vdb(jack)
meas ac r20 find rdb at=20
meas ac r1k find rdb at=1000
let e9 = r20 - r1k
echo "0,oggi,10,2,10k,e9_db,$&e9" >> /Users/roberto/EDA/.claude/worktrees/L48b/docs/preamp/data/2026-10-07/L48b/scatti/ac/ac_rumore.csv
destroy all
alter rload = 100k
alter rsrc = 1.5
noise v(jack) vsrc dec 50 20 20000 1
setplot noise2
let onu = onoise_total*1e6
echo "0,oggi,10,2,1.5,e5_uv,$&onu" >> /Users/roberto/EDA/.claude/worktrees/L48b/docs/preamp/data/2026-10-07/L48b/scatti/ac/ac_rumore.csv
destroy all
alter rsrc = 430
noise v(jack) vsrc dec 50 20 20000 1
setplot noise2
let onu = onoise_total*1e6
echo "0,oggi,10,2,430,e5_uv,$&onu" >> /Users/roberto/EDA/.claude/worktrees/L48b/docs/preamp/data/2026-10-07/L48b/scatti/ac/ac_rumore.csv
destroy all
alter rsrc = 1.5
* ---- ac cb1u g=0 att=1
alter ca = 1p
alter rbya = 1m
alter ctx = 1p
alter rbyt = 1m
alter cb = 1u
alter rbyb = 1e12
alter rgate = 1Meg
alter rbal = 1e12
alter vosa dc = 0
alter iosa dc = 0
alter rrgb = 1e+09
alter rrg10b = 1e+09
alter ra = 0.001
alter rb = 2057
alter rc = 7943
alter @vt1r[pwl] = [ 0 1 1 1 ]
alter @vt1s[pwl] = [ 0 0 1 0 ]
alter @vt2r[pwl] = [ 0 1 1 1 ]
alter @vt2s[pwl] = [ 0 0 1 0 ]
alter @vw1[pwl] = [ 0 1 1 1 ]
alter @vw2[pwl] = [ 0 0 1 0 ]
alter rload = 100k
alter rsrc = 1.5
ac dec 50 10 20k
let rdb = vdb(jack)
meas ac r20 find rdb at=20
meas ac r1k find rdb at=1000
let e9 = r20 - r1k
echo "1,cb1u,0,1,100k,e9_db,$&e9" >> /Users/roberto/EDA/.claude/worktrees/L48b/docs/preamp/data/2026-10-07/L48b/scatti/ac/ac_rumore.csv
destroy all
alter rload = 10k
alter rsrc = 1.5
ac dec 50 10 20k
let rdb = vdb(jack)
meas ac r20 find rdb at=20
meas ac r1k find rdb at=1000
let e9 = r20 - r1k
echo "1,cb1u,0,1,10k,e9_db,$&e9" >> /Users/roberto/EDA/.claude/worktrees/L48b/docs/preamp/data/2026-10-07/L48b/scatti/ac/ac_rumore.csv
destroy all
alter rload = 100k
alter rsrc = 1.5
noise v(jack) vsrc dec 50 20 20000 1
setplot noise2
let onu = onoise_total*1e6
echo "1,cb1u,0,1,1.5,e5_uv,$&onu" >> /Users/roberto/EDA/.claude/worktrees/L48b/docs/preamp/data/2026-10-07/L48b/scatti/ac/ac_rumore.csv
destroy all
alter rsrc = 430
noise v(jack) vsrc dec 50 20 20000 1
setplot noise2
let onu = onoise_total*1e6
echo "1,cb1u,0,1,430,e5_uv,$&onu" >> /Users/roberto/EDA/.claude/worktrees/L48b/docs/preamp/data/2026-10-07/L48b/scatti/ac/ac_rumore.csv
destroy all
alter rsrc = 1.5
* ---- ac cb1u g=0 att=2
alter ca = 1p
alter rbya = 1m
alter ctx = 1p
alter rbyt = 1m
alter cb = 1u
alter rbyb = 1e12
alter rgate = 1Meg
alter rbal = 1e12
alter vosa dc = 0
alter iosa dc = 0
alter rrgb = 1e+09
alter rrg10b = 1e+09
alter ra = 5000
alter rb = 0.001
alter rc = 5000
alter @vt1r[pwl] = [ 0 1 1 1 ]
alter @vt1s[pwl] = [ 0 0 1 0 ]
alter @vt2r[pwl] = [ 0 1 1 1 ]
alter @vt2s[pwl] = [ 0 0 1 0 ]
alter @vw1[pwl] = [ 0 1 1 1 ]
alter @vw2[pwl] = [ 0 0 1 0 ]
alter rload = 100k
alter rsrc = 1.5
ac dec 50 10 20k
let rdb = vdb(jack)
meas ac r20 find rdb at=20
meas ac r1k find rdb at=1000
let e9 = r20 - r1k
echo "1,cb1u,0,2,100k,e9_db,$&e9" >> /Users/roberto/EDA/.claude/worktrees/L48b/docs/preamp/data/2026-10-07/L48b/scatti/ac/ac_rumore.csv
destroy all
alter rload = 10k
alter rsrc = 1.5
ac dec 50 10 20k
let rdb = vdb(jack)
meas ac r20 find rdb at=20
meas ac r1k find rdb at=1000
let e9 = r20 - r1k
echo "1,cb1u,0,2,10k,e9_db,$&e9" >> /Users/roberto/EDA/.claude/worktrees/L48b/docs/preamp/data/2026-10-07/L48b/scatti/ac/ac_rumore.csv
destroy all
alter rload = 100k
alter rsrc = 1.5
noise v(jack) vsrc dec 50 20 20000 1
setplot noise2
let onu = onoise_total*1e6
echo "1,cb1u,0,2,1.5,e5_uv,$&onu" >> /Users/roberto/EDA/.claude/worktrees/L48b/docs/preamp/data/2026-10-07/L48b/scatti/ac/ac_rumore.csv
destroy all
alter rsrc = 430
noise v(jack) vsrc dec 50 20 20000 1
setplot noise2
let onu = onoise_total*1e6
echo "1,cb1u,0,2,430,e5_uv,$&onu" >> /Users/roberto/EDA/.claude/worktrees/L48b/docs/preamp/data/2026-10-07/L48b/scatti/ac/ac_rumore.csv
destroy all
alter rsrc = 1.5
* ---- ac cb1u g=10 att=1
alter ca = 1p
alter rbya = 1m
alter ctx = 1p
alter rbyt = 1m
alter cb = 1u
alter rbyb = 1e12
alter rgate = 1Meg
alter rbal = 1e12
alter vosa dc = 0
alter iosa dc = 0
alter rrgb = 0.1
alter rrg10b = 0.1
alter ra = 0.001
alter rb = 2057
alter rc = 7943
alter @vt1r[pwl] = [ 0 1 1 1 ]
alter @vt1s[pwl] = [ 0 0 1 0 ]
alter @vt2r[pwl] = [ 0 1 1 1 ]
alter @vt2s[pwl] = [ 0 0 1 0 ]
alter @vw1[pwl] = [ 0 1 1 1 ]
alter @vw2[pwl] = [ 0 0 1 0 ]
alter rload = 100k
alter rsrc = 1.5
ac dec 50 10 20k
let rdb = vdb(jack)
meas ac r20 find rdb at=20
meas ac r1k find rdb at=1000
let e9 = r20 - r1k
echo "1,cb1u,10,1,100k,e9_db,$&e9" >> /Users/roberto/EDA/.claude/worktrees/L48b/docs/preamp/data/2026-10-07/L48b/scatti/ac/ac_rumore.csv
destroy all
alter rload = 10k
alter rsrc = 1.5
ac dec 50 10 20k
let rdb = vdb(jack)
meas ac r20 find rdb at=20
meas ac r1k find rdb at=1000
let e9 = r20 - r1k
echo "1,cb1u,10,1,10k,e9_db,$&e9" >> /Users/roberto/EDA/.claude/worktrees/L48b/docs/preamp/data/2026-10-07/L48b/scatti/ac/ac_rumore.csv
destroy all
alter rload = 100k
alter rsrc = 1.5
noise v(jack) vsrc dec 50 20 20000 1
setplot noise2
let onu = onoise_total*1e6
echo "1,cb1u,10,1,1.5,e5_uv,$&onu" >> /Users/roberto/EDA/.claude/worktrees/L48b/docs/preamp/data/2026-10-07/L48b/scatti/ac/ac_rumore.csv
destroy all
alter rsrc = 430
noise v(jack) vsrc dec 50 20 20000 1
setplot noise2
let onu = onoise_total*1e6
echo "1,cb1u,10,1,430,e5_uv,$&onu" >> /Users/roberto/EDA/.claude/worktrees/L48b/docs/preamp/data/2026-10-07/L48b/scatti/ac/ac_rumore.csv
destroy all
alter rsrc = 1.5
* ---- ac cb1u g=10 att=2
alter ca = 1p
alter rbya = 1m
alter ctx = 1p
alter rbyt = 1m
alter cb = 1u
alter rbyb = 1e12
alter rgate = 1Meg
alter rbal = 1e12
alter vosa dc = 0
alter iosa dc = 0
alter rrgb = 0.1
alter rrg10b = 0.1
alter ra = 5000
alter rb = 0.001
alter rc = 5000
alter @vt1r[pwl] = [ 0 1 1 1 ]
alter @vt1s[pwl] = [ 0 0 1 0 ]
alter @vt2r[pwl] = [ 0 1 1 1 ]
alter @vt2s[pwl] = [ 0 0 1 0 ]
alter @vw1[pwl] = [ 0 1 1 1 ]
alter @vw2[pwl] = [ 0 0 1 0 ]
alter rload = 100k
alter rsrc = 1.5
ac dec 50 10 20k
let rdb = vdb(jack)
meas ac r20 find rdb at=20
meas ac r1k find rdb at=1000
let e9 = r20 - r1k
echo "1,cb1u,10,2,100k,e9_db,$&e9" >> /Users/roberto/EDA/.claude/worktrees/L48b/docs/preamp/data/2026-10-07/L48b/scatti/ac/ac_rumore.csv
destroy all
alter rload = 10k
alter rsrc = 1.5
ac dec 50 10 20k
let rdb = vdb(jack)
meas ac r20 find rdb at=20
meas ac r1k find rdb at=1000
let e9 = r20 - r1k
echo "1,cb1u,10,2,10k,e9_db,$&e9" >> /Users/roberto/EDA/.claude/worktrees/L48b/docs/preamp/data/2026-10-07/L48b/scatti/ac/ac_rumore.csv
destroy all
alter rload = 100k
alter rsrc = 1.5
noise v(jack) vsrc dec 50 20 20000 1
setplot noise2
let onu = onoise_total*1e6
echo "1,cb1u,10,2,1.5,e5_uv,$&onu" >> /Users/roberto/EDA/.claude/worktrees/L48b/docs/preamp/data/2026-10-07/L48b/scatti/ac/ac_rumore.csv
destroy all
alter rsrc = 430
noise v(jack) vsrc dec 50 20 20000 1
setplot noise2
let onu = onoise_total*1e6
echo "1,cb1u,10,2,430,e5_uv,$&onu" >> /Users/roberto/EDA/.claude/worktrees/L48b/docs/preamp/data/2026-10-07/L48b/scatti/ac/ac_rumore.csv
destroy all
alter rsrc = 1.5
* ---- ac ca47u g=0 att=1
alter ca = 47u
alter rbya = 1e12
alter ctx = 1p
alter rbyt = 1m
alter cb = 1p
alter rbyb = 1m
alter rgate = 1e12
alter rbal = 1e12
alter vosa dc = 0
alter iosa dc = 0
alter rrgb = 1e+09
alter rrg10b = 1e+09
alter ra = 0.001
alter rb = 2057
alter rc = 7943
alter @vt1r[pwl] = [ 0 1 1 1 ]
alter @vt1s[pwl] = [ 0 0 1 0 ]
alter @vt2r[pwl] = [ 0 1 1 1 ]
alter @vt2s[pwl] = [ 0 0 1 0 ]
alter @vw1[pwl] = [ 0 1 1 1 ]
alter @vw2[pwl] = [ 0 0 1 0 ]
alter rload = 100k
alter rsrc = 1.5
ac dec 50 10 20k
let rdb = vdb(jack)
meas ac r20 find rdb at=20
meas ac r1k find rdb at=1000
let e9 = r20 - r1k
echo "2,ca47u,0,1,100k,e9_db,$&e9" >> /Users/roberto/EDA/.claude/worktrees/L48b/docs/preamp/data/2026-10-07/L48b/scatti/ac/ac_rumore.csv
destroy all
alter rload = 10k
alter rsrc = 1.5
ac dec 50 10 20k
let rdb = vdb(jack)
meas ac r20 find rdb at=20
meas ac r1k find rdb at=1000
let e9 = r20 - r1k
echo "2,ca47u,0,1,10k,e9_db,$&e9" >> /Users/roberto/EDA/.claude/worktrees/L48b/docs/preamp/data/2026-10-07/L48b/scatti/ac/ac_rumore.csv
destroy all
alter rload = 100k
alter rsrc = 1.5
noise v(jack) vsrc dec 50 20 20000 1
setplot noise2
let onu = onoise_total*1e6
echo "2,ca47u,0,1,1.5,e5_uv,$&onu" >> /Users/roberto/EDA/.claude/worktrees/L48b/docs/preamp/data/2026-10-07/L48b/scatti/ac/ac_rumore.csv
destroy all
alter rsrc = 430
noise v(jack) vsrc dec 50 20 20000 1
setplot noise2
let onu = onoise_total*1e6
echo "2,ca47u,0,1,430,e5_uv,$&onu" >> /Users/roberto/EDA/.claude/worktrees/L48b/docs/preamp/data/2026-10-07/L48b/scatti/ac/ac_rumore.csv
destroy all
alter rsrc = 1.5
* ---- ac ca47u g=0 att=2
alter ca = 47u
alter rbya = 1e12
alter ctx = 1p
alter rbyt = 1m
alter cb = 1p
alter rbyb = 1m
alter rgate = 1e12
alter rbal = 1e12
alter vosa dc = 0
alter iosa dc = 0
alter rrgb = 1e+09
alter rrg10b = 1e+09
alter ra = 5000
alter rb = 0.001
alter rc = 5000
alter @vt1r[pwl] = [ 0 1 1 1 ]
alter @vt1s[pwl] = [ 0 0 1 0 ]
alter @vt2r[pwl] = [ 0 1 1 1 ]
alter @vt2s[pwl] = [ 0 0 1 0 ]
alter @vw1[pwl] = [ 0 1 1 1 ]
alter @vw2[pwl] = [ 0 0 1 0 ]
alter rload = 100k
alter rsrc = 1.5
ac dec 50 10 20k
let rdb = vdb(jack)
meas ac r20 find rdb at=20
meas ac r1k find rdb at=1000
let e9 = r20 - r1k
echo "2,ca47u,0,2,100k,e9_db,$&e9" >> /Users/roberto/EDA/.claude/worktrees/L48b/docs/preamp/data/2026-10-07/L48b/scatti/ac/ac_rumore.csv
destroy all
alter rload = 10k
alter rsrc = 1.5
ac dec 50 10 20k
let rdb = vdb(jack)
meas ac r20 find rdb at=20
meas ac r1k find rdb at=1000
let e9 = r20 - r1k
echo "2,ca47u,0,2,10k,e9_db,$&e9" >> /Users/roberto/EDA/.claude/worktrees/L48b/docs/preamp/data/2026-10-07/L48b/scatti/ac/ac_rumore.csv
destroy all
alter rload = 100k
alter rsrc = 1.5
noise v(jack) vsrc dec 50 20 20000 1
setplot noise2
let onu = onoise_total*1e6
echo "2,ca47u,0,2,1.5,e5_uv,$&onu" >> /Users/roberto/EDA/.claude/worktrees/L48b/docs/preamp/data/2026-10-07/L48b/scatti/ac/ac_rumore.csv
destroy all
alter rsrc = 430
noise v(jack) vsrc dec 50 20 20000 1
setplot noise2
let onu = onoise_total*1e6
echo "2,ca47u,0,2,430,e5_uv,$&onu" >> /Users/roberto/EDA/.claude/worktrees/L48b/docs/preamp/data/2026-10-07/L48b/scatti/ac/ac_rumore.csv
destroy all
alter rsrc = 1.5
* ---- ac ca47u g=10 att=1
alter ca = 47u
alter rbya = 1e12
alter ctx = 1p
alter rbyt = 1m
alter cb = 1p
alter rbyb = 1m
alter rgate = 1e12
alter rbal = 1e12
alter vosa dc = 0
alter iosa dc = 0
alter rrgb = 0.1
alter rrg10b = 0.1
alter ra = 0.001
alter rb = 2057
alter rc = 7943
alter @vt1r[pwl] = [ 0 1 1 1 ]
alter @vt1s[pwl] = [ 0 0 1 0 ]
alter @vt2r[pwl] = [ 0 1 1 1 ]
alter @vt2s[pwl] = [ 0 0 1 0 ]
alter @vw1[pwl] = [ 0 1 1 1 ]
alter @vw2[pwl] = [ 0 0 1 0 ]
alter rload = 100k
alter rsrc = 1.5
ac dec 50 10 20k
let rdb = vdb(jack)
meas ac r20 find rdb at=20
meas ac r1k find rdb at=1000
let e9 = r20 - r1k
echo "2,ca47u,10,1,100k,e9_db,$&e9" >> /Users/roberto/EDA/.claude/worktrees/L48b/docs/preamp/data/2026-10-07/L48b/scatti/ac/ac_rumore.csv
destroy all
alter rload = 10k
alter rsrc = 1.5
ac dec 50 10 20k
let rdb = vdb(jack)
meas ac r20 find rdb at=20
meas ac r1k find rdb at=1000
let e9 = r20 - r1k
echo "2,ca47u,10,1,10k,e9_db,$&e9" >> /Users/roberto/EDA/.claude/worktrees/L48b/docs/preamp/data/2026-10-07/L48b/scatti/ac/ac_rumore.csv
destroy all
alter rload = 100k
alter rsrc = 1.5
noise v(jack) vsrc dec 50 20 20000 1
setplot noise2
let onu = onoise_total*1e6
echo "2,ca47u,10,1,1.5,e5_uv,$&onu" >> /Users/roberto/EDA/.claude/worktrees/L48b/docs/preamp/data/2026-10-07/L48b/scatti/ac/ac_rumore.csv
destroy all
alter rsrc = 430
noise v(jack) vsrc dec 50 20 20000 1
setplot noise2
let onu = onoise_total*1e6
echo "2,ca47u,10,1,430,e5_uv,$&onu" >> /Users/roberto/EDA/.claude/worktrees/L48b/docs/preamp/data/2026-10-07/L48b/scatti/ac/ac_rumore.csv
destroy all
alter rsrc = 1.5
* ---- ac ca47u g=10 att=2
alter ca = 47u
alter rbya = 1e12
alter ctx = 1p
alter rbyt = 1m
alter cb = 1p
alter rbyb = 1m
alter rgate = 1e12
alter rbal = 1e12
alter vosa dc = 0
alter iosa dc = 0
alter rrgb = 0.1
alter rrg10b = 0.1
alter ra = 5000
alter rb = 0.001
alter rc = 5000
alter @vt1r[pwl] = [ 0 1 1 1 ]
alter @vt1s[pwl] = [ 0 0 1 0 ]
alter @vt2r[pwl] = [ 0 1 1 1 ]
alter @vt2s[pwl] = [ 0 0 1 0 ]
alter @vw1[pwl] = [ 0 1 1 1 ]
alter @vw2[pwl] = [ 0 0 1 0 ]
alter rload = 100k
alter rsrc = 1.5
ac dec 50 10 20k
let rdb = vdb(jack)
meas ac r20 find rdb at=20
meas ac r1k find rdb at=1000
let e9 = r20 - r1k
echo "2,ca47u,10,2,100k,e9_db,$&e9" >> /Users/roberto/EDA/.claude/worktrees/L48b/docs/preamp/data/2026-10-07/L48b/scatti/ac/ac_rumore.csv
destroy all
alter rload = 10k
alter rsrc = 1.5
ac dec 50 10 20k
let rdb = vdb(jack)
meas ac r20 find rdb at=20
meas ac r1k find rdb at=1000
let e9 = r20 - r1k
echo "2,ca47u,10,2,10k,e9_db,$&e9" >> /Users/roberto/EDA/.claude/worktrees/L48b/docs/preamp/data/2026-10-07/L48b/scatti/ac/ac_rumore.csv
destroy all
alter rload = 100k
alter rsrc = 1.5
noise v(jack) vsrc dec 50 20 20000 1
setplot noise2
let onu = onoise_total*1e6
echo "2,ca47u,10,2,1.5,e5_uv,$&onu" >> /Users/roberto/EDA/.claude/worktrees/L48b/docs/preamp/data/2026-10-07/L48b/scatti/ac/ac_rumore.csv
destroy all
alter rsrc = 430
noise v(jack) vsrc dec 50 20 20000 1
setplot noise2
let onu = onoise_total*1e6
echo "2,ca47u,10,2,430,e5_uv,$&onu" >> /Users/roberto/EDA/.claude/worktrees/L48b/docs/preamp/data/2026-10-07/L48b/scatti/ac/ac_rumore.csv
destroy all
alter rsrc = 1.5
* ---- ac ca68u g=0 att=1
alter ca = 68u
alter rbya = 1e12
alter ctx = 1p
alter rbyt = 1m
alter cb = 1p
alter rbyb = 1m
alter rgate = 1e12
alter rbal = 1e12
alter vosa dc = 0
alter iosa dc = 0
alter rrgb = 1e+09
alter rrg10b = 1e+09
alter ra = 0.001
alter rb = 2057
alter rc = 7943
alter @vt1r[pwl] = [ 0 1 1 1 ]
alter @vt1s[pwl] = [ 0 0 1 0 ]
alter @vt2r[pwl] = [ 0 1 1 1 ]
alter @vt2s[pwl] = [ 0 0 1 0 ]
alter @vw1[pwl] = [ 0 1 1 1 ]
alter @vw2[pwl] = [ 0 0 1 0 ]
alter rload = 100k
alter rsrc = 1.5
ac dec 50 10 20k
let rdb = vdb(jack)
meas ac r20 find rdb at=20
meas ac r1k find rdb at=1000
let e9 = r20 - r1k
echo "2,ca68u,0,1,100k,e9_db,$&e9" >> /Users/roberto/EDA/.claude/worktrees/L48b/docs/preamp/data/2026-10-07/L48b/scatti/ac/ac_rumore.csv
destroy all
alter rload = 10k
alter rsrc = 1.5
ac dec 50 10 20k
let rdb = vdb(jack)
meas ac r20 find rdb at=20
meas ac r1k find rdb at=1000
let e9 = r20 - r1k
echo "2,ca68u,0,1,10k,e9_db,$&e9" >> /Users/roberto/EDA/.claude/worktrees/L48b/docs/preamp/data/2026-10-07/L48b/scatti/ac/ac_rumore.csv
destroy all
alter rload = 100k
alter rsrc = 1.5
noise v(jack) vsrc dec 50 20 20000 1
setplot noise2
let onu = onoise_total*1e6
echo "2,ca68u,0,1,1.5,e5_uv,$&onu" >> /Users/roberto/EDA/.claude/worktrees/L48b/docs/preamp/data/2026-10-07/L48b/scatti/ac/ac_rumore.csv
destroy all
alter rsrc = 430
noise v(jack) vsrc dec 50 20 20000 1
setplot noise2
let onu = onoise_total*1e6
echo "2,ca68u,0,1,430,e5_uv,$&onu" >> /Users/roberto/EDA/.claude/worktrees/L48b/docs/preamp/data/2026-10-07/L48b/scatti/ac/ac_rumore.csv
destroy all
alter rsrc = 1.5
* ---- ac ca68u g=0 att=2
alter ca = 68u
alter rbya = 1e12
alter ctx = 1p
alter rbyt = 1m
alter cb = 1p
alter rbyb = 1m
alter rgate = 1e12
alter rbal = 1e12
alter vosa dc = 0
alter iosa dc = 0
alter rrgb = 1e+09
alter rrg10b = 1e+09
alter ra = 5000
alter rb = 0.001
alter rc = 5000
alter @vt1r[pwl] = [ 0 1 1 1 ]
alter @vt1s[pwl] = [ 0 0 1 0 ]
alter @vt2r[pwl] = [ 0 1 1 1 ]
alter @vt2s[pwl] = [ 0 0 1 0 ]
alter @vw1[pwl] = [ 0 1 1 1 ]
alter @vw2[pwl] = [ 0 0 1 0 ]
alter rload = 100k
alter rsrc = 1.5
ac dec 50 10 20k
let rdb = vdb(jack)
meas ac r20 find rdb at=20
meas ac r1k find rdb at=1000
let e9 = r20 - r1k
echo "2,ca68u,0,2,100k,e9_db,$&e9" >> /Users/roberto/EDA/.claude/worktrees/L48b/docs/preamp/data/2026-10-07/L48b/scatti/ac/ac_rumore.csv
destroy all
alter rload = 10k
alter rsrc = 1.5
ac dec 50 10 20k
let rdb = vdb(jack)
meas ac r20 find rdb at=20
meas ac r1k find rdb at=1000
let e9 = r20 - r1k
echo "2,ca68u,0,2,10k,e9_db,$&e9" >> /Users/roberto/EDA/.claude/worktrees/L48b/docs/preamp/data/2026-10-07/L48b/scatti/ac/ac_rumore.csv
destroy all
alter rload = 100k
alter rsrc = 1.5
noise v(jack) vsrc dec 50 20 20000 1
setplot noise2
let onu = onoise_total*1e6
echo "2,ca68u,0,2,1.5,e5_uv,$&onu" >> /Users/roberto/EDA/.claude/worktrees/L48b/docs/preamp/data/2026-10-07/L48b/scatti/ac/ac_rumore.csv
destroy all
alter rsrc = 430
noise v(jack) vsrc dec 50 20 20000 1
setplot noise2
let onu = onoise_total*1e6
echo "2,ca68u,0,2,430,e5_uv,$&onu" >> /Users/roberto/EDA/.claude/worktrees/L48b/docs/preamp/data/2026-10-07/L48b/scatti/ac/ac_rumore.csv
destroy all
alter rsrc = 1.5
* ---- ac ca68u g=10 att=1
alter ca = 68u
alter rbya = 1e12
alter ctx = 1p
alter rbyt = 1m
alter cb = 1p
alter rbyb = 1m
alter rgate = 1e12
alter rbal = 1e12
alter vosa dc = 0
alter iosa dc = 0
alter rrgb = 0.1
alter rrg10b = 0.1
alter ra = 0.001
alter rb = 2057
alter rc = 7943
alter @vt1r[pwl] = [ 0 1 1 1 ]
alter @vt1s[pwl] = [ 0 0 1 0 ]
alter @vt2r[pwl] = [ 0 1 1 1 ]
alter @vt2s[pwl] = [ 0 0 1 0 ]
alter @vw1[pwl] = [ 0 1 1 1 ]
alter @vw2[pwl] = [ 0 0 1 0 ]
alter rload = 100k
alter rsrc = 1.5
ac dec 50 10 20k
let rdb = vdb(jack)
meas ac r20 find rdb at=20
meas ac r1k find rdb at=1000
let e9 = r20 - r1k
echo "2,ca68u,10,1,100k,e9_db,$&e9" >> /Users/roberto/EDA/.claude/worktrees/L48b/docs/preamp/data/2026-10-07/L48b/scatti/ac/ac_rumore.csv
destroy all
alter rload = 10k
alter rsrc = 1.5
ac dec 50 10 20k
let rdb = vdb(jack)
meas ac r20 find rdb at=20
meas ac r1k find rdb at=1000
let e9 = r20 - r1k
echo "2,ca68u,10,1,10k,e9_db,$&e9" >> /Users/roberto/EDA/.claude/worktrees/L48b/docs/preamp/data/2026-10-07/L48b/scatti/ac/ac_rumore.csv
destroy all
alter rload = 100k
alter rsrc = 1.5
noise v(jack) vsrc dec 50 20 20000 1
setplot noise2
let onu = onoise_total*1e6
echo "2,ca68u,10,1,1.5,e5_uv,$&onu" >> /Users/roberto/EDA/.claude/worktrees/L48b/docs/preamp/data/2026-10-07/L48b/scatti/ac/ac_rumore.csv
destroy all
alter rsrc = 430
noise v(jack) vsrc dec 50 20 20000 1
setplot noise2
let onu = onoise_total*1e6
echo "2,ca68u,10,1,430,e5_uv,$&onu" >> /Users/roberto/EDA/.claude/worktrees/L48b/docs/preamp/data/2026-10-07/L48b/scatti/ac/ac_rumore.csv
destroy all
alter rsrc = 1.5
* ---- ac ca68u g=10 att=2
alter ca = 68u
alter rbya = 1e12
alter ctx = 1p
alter rbyt = 1m
alter cb = 1p
alter rbyb = 1m
alter rgate = 1e12
alter rbal = 1e12
alter vosa dc = 0
alter iosa dc = 0
alter rrgb = 0.1
alter rrg10b = 0.1
alter ra = 5000
alter rb = 0.001
alter rc = 5000
alter @vt1r[pwl] = [ 0 1 1 1 ]
alter @vt1s[pwl] = [ 0 0 1 0 ]
alter @vt2r[pwl] = [ 0 1 1 1 ]
alter @vt2s[pwl] = [ 0 0 1 0 ]
alter @vw1[pwl] = [ 0 1 1 1 ]
alter @vw2[pwl] = [ 0 0 1 0 ]
alter rload = 100k
alter rsrc = 1.5
ac dec 50 10 20k
let rdb = vdb(jack)
meas ac r20 find rdb at=20
meas ac r1k find rdb at=1000
let e9 = r20 - r1k
echo "2,ca68u,10,2,100k,e9_db,$&e9" >> /Users/roberto/EDA/.claude/worktrees/L48b/docs/preamp/data/2026-10-07/L48b/scatti/ac/ac_rumore.csv
destroy all
alter rload = 10k
alter rsrc = 1.5
ac dec 50 10 20k
let rdb = vdb(jack)
meas ac r20 find rdb at=20
meas ac r1k find rdb at=1000
let e9 = r20 - r1k
echo "2,ca68u,10,2,10k,e9_db,$&e9" >> /Users/roberto/EDA/.claude/worktrees/L48b/docs/preamp/data/2026-10-07/L48b/scatti/ac/ac_rumore.csv
destroy all
alter rload = 100k
alter rsrc = 1.5
noise v(jack) vsrc dec 50 20 20000 1
setplot noise2
let onu = onoise_total*1e6
echo "2,ca68u,10,2,1.5,e5_uv,$&onu" >> /Users/roberto/EDA/.claude/worktrees/L48b/docs/preamp/data/2026-10-07/L48b/scatti/ac/ac_rumore.csv
destroy all
alter rsrc = 430
noise v(jack) vsrc dec 50 20 20000 1
setplot noise2
let onu = onoise_total*1e6
echo "2,ca68u,10,2,430,e5_uv,$&onu" >> /Users/roberto/EDA/.claude/worktrees/L48b/docs/preamp/data/2026-10-07/L48b/scatti/ac/ac_rumore.csv
destroy all
alter rsrc = 1.5
* ---- ac ca100u g=0 att=1
alter ca = 100u
alter rbya = 1e12
alter ctx = 1p
alter rbyt = 1m
alter cb = 1p
alter rbyb = 1m
alter rgate = 1e12
alter rbal = 1e12
alter vosa dc = 0
alter iosa dc = 0
alter rrgb = 1e+09
alter rrg10b = 1e+09
alter ra = 0.001
alter rb = 2057
alter rc = 7943
alter @vt1r[pwl] = [ 0 1 1 1 ]
alter @vt1s[pwl] = [ 0 0 1 0 ]
alter @vt2r[pwl] = [ 0 1 1 1 ]
alter @vt2s[pwl] = [ 0 0 1 0 ]
alter @vw1[pwl] = [ 0 1 1 1 ]
alter @vw2[pwl] = [ 0 0 1 0 ]
alter rload = 100k
alter rsrc = 1.5
ac dec 50 10 20k
let rdb = vdb(jack)
meas ac r20 find rdb at=20
meas ac r1k find rdb at=1000
let e9 = r20 - r1k
echo "2,ca100u,0,1,100k,e9_db,$&e9" >> /Users/roberto/EDA/.claude/worktrees/L48b/docs/preamp/data/2026-10-07/L48b/scatti/ac/ac_rumore.csv
destroy all
alter rload = 10k
alter rsrc = 1.5
ac dec 50 10 20k
let rdb = vdb(jack)
meas ac r20 find rdb at=20
meas ac r1k find rdb at=1000
let e9 = r20 - r1k
echo "2,ca100u,0,1,10k,e9_db,$&e9" >> /Users/roberto/EDA/.claude/worktrees/L48b/docs/preamp/data/2026-10-07/L48b/scatti/ac/ac_rumore.csv
destroy all
alter rload = 100k
alter rsrc = 1.5
noise v(jack) vsrc dec 50 20 20000 1
setplot noise2
let onu = onoise_total*1e6
echo "2,ca100u,0,1,1.5,e5_uv,$&onu" >> /Users/roberto/EDA/.claude/worktrees/L48b/docs/preamp/data/2026-10-07/L48b/scatti/ac/ac_rumore.csv
destroy all
alter rsrc = 430
noise v(jack) vsrc dec 50 20 20000 1
setplot noise2
let onu = onoise_total*1e6
echo "2,ca100u,0,1,430,e5_uv,$&onu" >> /Users/roberto/EDA/.claude/worktrees/L48b/docs/preamp/data/2026-10-07/L48b/scatti/ac/ac_rumore.csv
destroy all
alter rsrc = 1.5
* ---- ac ca100u g=0 att=2
alter ca = 100u
alter rbya = 1e12
alter ctx = 1p
alter rbyt = 1m
alter cb = 1p
alter rbyb = 1m
alter rgate = 1e12
alter rbal = 1e12
alter vosa dc = 0
alter iosa dc = 0
alter rrgb = 1e+09
alter rrg10b = 1e+09
alter ra = 5000
alter rb = 0.001
alter rc = 5000
alter @vt1r[pwl] = [ 0 1 1 1 ]
alter @vt1s[pwl] = [ 0 0 1 0 ]
alter @vt2r[pwl] = [ 0 1 1 1 ]
alter @vt2s[pwl] = [ 0 0 1 0 ]
alter @vw1[pwl] = [ 0 1 1 1 ]
alter @vw2[pwl] = [ 0 0 1 0 ]
alter rload = 100k
alter rsrc = 1.5
ac dec 50 10 20k
let rdb = vdb(jack)
meas ac r20 find rdb at=20
meas ac r1k find rdb at=1000
let e9 = r20 - r1k
echo "2,ca100u,0,2,100k,e9_db,$&e9" >> /Users/roberto/EDA/.claude/worktrees/L48b/docs/preamp/data/2026-10-07/L48b/scatti/ac/ac_rumore.csv
destroy all
alter rload = 10k
alter rsrc = 1.5
ac dec 50 10 20k
let rdb = vdb(jack)
meas ac r20 find rdb at=20
meas ac r1k find rdb at=1000
let e9 = r20 - r1k
echo "2,ca100u,0,2,10k,e9_db,$&e9" >> /Users/roberto/EDA/.claude/worktrees/L48b/docs/preamp/data/2026-10-07/L48b/scatti/ac/ac_rumore.csv
destroy all
alter rload = 100k
alter rsrc = 1.5
noise v(jack) vsrc dec 50 20 20000 1
setplot noise2
let onu = onoise_total*1e6
echo "2,ca100u,0,2,1.5,e5_uv,$&onu" >> /Users/roberto/EDA/.claude/worktrees/L48b/docs/preamp/data/2026-10-07/L48b/scatti/ac/ac_rumore.csv
destroy all
alter rsrc = 430
noise v(jack) vsrc dec 50 20 20000 1
setplot noise2
let onu = onoise_total*1e6
echo "2,ca100u,0,2,430,e5_uv,$&onu" >> /Users/roberto/EDA/.claude/worktrees/L48b/docs/preamp/data/2026-10-07/L48b/scatti/ac/ac_rumore.csv
destroy all
alter rsrc = 1.5
* ---- ac ca100u g=10 att=1
alter ca = 100u
alter rbya = 1e12
alter ctx = 1p
alter rbyt = 1m
alter cb = 1p
alter rbyb = 1m
alter rgate = 1e12
alter rbal = 1e12
alter vosa dc = 0
alter iosa dc = 0
alter rrgb = 0.1
alter rrg10b = 0.1
alter ra = 0.001
alter rb = 2057
alter rc = 7943
alter @vt1r[pwl] = [ 0 1 1 1 ]
alter @vt1s[pwl] = [ 0 0 1 0 ]
alter @vt2r[pwl] = [ 0 1 1 1 ]
alter @vt2s[pwl] = [ 0 0 1 0 ]
alter @vw1[pwl] = [ 0 1 1 1 ]
alter @vw2[pwl] = [ 0 0 1 0 ]
alter rload = 100k
alter rsrc = 1.5
ac dec 50 10 20k
let rdb = vdb(jack)
meas ac r20 find rdb at=20
meas ac r1k find rdb at=1000
let e9 = r20 - r1k
echo "2,ca100u,10,1,100k,e9_db,$&e9" >> /Users/roberto/EDA/.claude/worktrees/L48b/docs/preamp/data/2026-10-07/L48b/scatti/ac/ac_rumore.csv
destroy all
alter rload = 10k
alter rsrc = 1.5
ac dec 50 10 20k
let rdb = vdb(jack)
meas ac r20 find rdb at=20
meas ac r1k find rdb at=1000
let e9 = r20 - r1k
echo "2,ca100u,10,1,10k,e9_db,$&e9" >> /Users/roberto/EDA/.claude/worktrees/L48b/docs/preamp/data/2026-10-07/L48b/scatti/ac/ac_rumore.csv
destroy all
alter rload = 100k
alter rsrc = 1.5
noise v(jack) vsrc dec 50 20 20000 1
setplot noise2
let onu = onoise_total*1e6
echo "2,ca100u,10,1,1.5,e5_uv,$&onu" >> /Users/roberto/EDA/.claude/worktrees/L48b/docs/preamp/data/2026-10-07/L48b/scatti/ac/ac_rumore.csv
destroy all
alter rsrc = 430
noise v(jack) vsrc dec 50 20 20000 1
setplot noise2
let onu = onoise_total*1e6
echo "2,ca100u,10,1,430,e5_uv,$&onu" >> /Users/roberto/EDA/.claude/worktrees/L48b/docs/preamp/data/2026-10-07/L48b/scatti/ac/ac_rumore.csv
destroy all
alter rsrc = 1.5
* ---- ac ca100u g=10 att=2
alter ca = 100u
alter rbya = 1e12
alter ctx = 1p
alter rbyt = 1m
alter cb = 1p
alter rbyb = 1m
alter rgate = 1e12
alter rbal = 1e12
alter vosa dc = 0
alter iosa dc = 0
alter rrgb = 0.1
alter rrg10b = 0.1
alter ra = 5000
alter rb = 0.001
alter rc = 5000
alter @vt1r[pwl] = [ 0 1 1 1 ]
alter @vt1s[pwl] = [ 0 0 1 0 ]
alter @vt2r[pwl] = [ 0 1 1 1 ]
alter @vt2s[pwl] = [ 0 0 1 0 ]
alter @vw1[pwl] = [ 0 1 1 1 ]
alter @vw2[pwl] = [ 0 0 1 0 ]
alter rload = 100k
alter rsrc = 1.5
ac dec 50 10 20k
let rdb = vdb(jack)
meas ac r20 find rdb at=20
meas ac r1k find rdb at=1000
let e9 = r20 - r1k
echo "2,ca100u,10,2,100k,e9_db,$&e9" >> /Users/roberto/EDA/.claude/worktrees/L48b/docs/preamp/data/2026-10-07/L48b/scatti/ac/ac_rumore.csv
destroy all
alter rload = 10k
alter rsrc = 1.5
ac dec 50 10 20k
let rdb = vdb(jack)
meas ac r20 find rdb at=20
meas ac r1k find rdb at=1000
let e9 = r20 - r1k
echo "2,ca100u,10,2,10k,e9_db,$&e9" >> /Users/roberto/EDA/.claude/worktrees/L48b/docs/preamp/data/2026-10-07/L48b/scatti/ac/ac_rumore.csv
destroy all
alter rload = 100k
alter rsrc = 1.5
noise v(jack) vsrc dec 50 20 20000 1
setplot noise2
let onu = onoise_total*1e6
echo "2,ca100u,10,2,1.5,e5_uv,$&onu" >> /Users/roberto/EDA/.claude/worktrees/L48b/docs/preamp/data/2026-10-07/L48b/scatti/ac/ac_rumore.csv
destroy all
alter rsrc = 430
noise v(jack) vsrc dec 50 20 20000 1
setplot noise2
let onu = onoise_total*1e6
echo "2,ca100u,10,2,430,e5_uv,$&onu" >> /Users/roberto/EDA/.claude/worktrees/L48b/docs/preamp/data/2026-10-07/L48b/scatti/ac/ac_rumore.csv
destroy all
alter rsrc = 1.5
* ---- ac ct10u g=0 att=1
alter ca = 1p
alter rbya = 1m
alter ctx = 10u
alter rbyt = 1e12
alter cb = 1p
alter rbyb = 1m
alter rgate = 1e12
alter rbal = 1e12
alter vosa dc = 0
alter iosa dc = 0
alter rrgb = 1e+09
alter rrg10b = 1e+09
alter ra = 0.001
alter rb = 2057
alter rc = 7943
alter @vt1r[pwl] = [ 0 1 1 1 ]
alter @vt1s[pwl] = [ 0 0 1 0 ]
alter @vt2r[pwl] = [ 0 1 1 1 ]
alter @vt2s[pwl] = [ 0 0 1 0 ]
alter @vw1[pwl] = [ 0 1 1 1 ]
alter @vw2[pwl] = [ 0 0 1 0 ]
alter rload = 100k
alter rsrc = 1.5
ac dec 50 10 20k
let rdb = vdb(jack)
meas ac r20 find rdb at=20
meas ac r1k find rdb at=1000
let e9 = r20 - r1k
echo "3,ct10u,0,1,100k,e9_db,$&e9" >> /Users/roberto/EDA/.claude/worktrees/L48b/docs/preamp/data/2026-10-07/L48b/scatti/ac/ac_rumore.csv
destroy all
alter rload = 10k
alter rsrc = 1.5
ac dec 50 10 20k
let rdb = vdb(jack)
meas ac r20 find rdb at=20
meas ac r1k find rdb at=1000
let e9 = r20 - r1k
echo "3,ct10u,0,1,10k,e9_db,$&e9" >> /Users/roberto/EDA/.claude/worktrees/L48b/docs/preamp/data/2026-10-07/L48b/scatti/ac/ac_rumore.csv
destroy all
alter rload = 100k
alter rsrc = 1.5
noise v(jack) vsrc dec 50 20 20000 1
setplot noise2
let onu = onoise_total*1e6
echo "3,ct10u,0,1,1.5,e5_uv,$&onu" >> /Users/roberto/EDA/.claude/worktrees/L48b/docs/preamp/data/2026-10-07/L48b/scatti/ac/ac_rumore.csv
destroy all
alter rsrc = 430
noise v(jack) vsrc dec 50 20 20000 1
setplot noise2
let onu = onoise_total*1e6
echo "3,ct10u,0,1,430,e5_uv,$&onu" >> /Users/roberto/EDA/.claude/worktrees/L48b/docs/preamp/data/2026-10-07/L48b/scatti/ac/ac_rumore.csv
destroy all
alter rsrc = 1.5
* ---- ac ct10u g=0 att=2
alter ca = 1p
alter rbya = 1m
alter ctx = 10u
alter rbyt = 1e12
alter cb = 1p
alter rbyb = 1m
alter rgate = 1e12
alter rbal = 1e12
alter vosa dc = 0
alter iosa dc = 0
alter rrgb = 1e+09
alter rrg10b = 1e+09
alter ra = 5000
alter rb = 0.001
alter rc = 5000
alter @vt1r[pwl] = [ 0 1 1 1 ]
alter @vt1s[pwl] = [ 0 0 1 0 ]
alter @vt2r[pwl] = [ 0 1 1 1 ]
alter @vt2s[pwl] = [ 0 0 1 0 ]
alter @vw1[pwl] = [ 0 1 1 1 ]
alter @vw2[pwl] = [ 0 0 1 0 ]
alter rload = 100k
alter rsrc = 1.5
ac dec 50 10 20k
let rdb = vdb(jack)
meas ac r20 find rdb at=20
meas ac r1k find rdb at=1000
let e9 = r20 - r1k
echo "3,ct10u,0,2,100k,e9_db,$&e9" >> /Users/roberto/EDA/.claude/worktrees/L48b/docs/preamp/data/2026-10-07/L48b/scatti/ac/ac_rumore.csv
destroy all
alter rload = 10k
alter rsrc = 1.5
ac dec 50 10 20k
let rdb = vdb(jack)
meas ac r20 find rdb at=20
meas ac r1k find rdb at=1000
let e9 = r20 - r1k
echo "3,ct10u,0,2,10k,e9_db,$&e9" >> /Users/roberto/EDA/.claude/worktrees/L48b/docs/preamp/data/2026-10-07/L48b/scatti/ac/ac_rumore.csv
destroy all
alter rload = 100k
alter rsrc = 1.5
noise v(jack) vsrc dec 50 20 20000 1
setplot noise2
let onu = onoise_total*1e6
echo "3,ct10u,0,2,1.5,e5_uv,$&onu" >> /Users/roberto/EDA/.claude/worktrees/L48b/docs/preamp/data/2026-10-07/L48b/scatti/ac/ac_rumore.csv
destroy all
alter rsrc = 430
noise v(jack) vsrc dec 50 20 20000 1
setplot noise2
let onu = onoise_total*1e6
echo "3,ct10u,0,2,430,e5_uv,$&onu" >> /Users/roberto/EDA/.claude/worktrees/L48b/docs/preamp/data/2026-10-07/L48b/scatti/ac/ac_rumore.csv
destroy all
alter rsrc = 1.5
* ---- ac ct10u g=10 att=1
alter ca = 1p
alter rbya = 1m
alter ctx = 10u
alter rbyt = 1e12
alter cb = 1p
alter rbyb = 1m
alter rgate = 1e12
alter rbal = 1e12
alter vosa dc = 0
alter iosa dc = 0
alter rrgb = 0.1
alter rrg10b = 0.1
alter ra = 0.001
alter rb = 2057
alter rc = 7943
alter @vt1r[pwl] = [ 0 1 1 1 ]
alter @vt1s[pwl] = [ 0 0 1 0 ]
alter @vt2r[pwl] = [ 0 1 1 1 ]
alter @vt2s[pwl] = [ 0 0 1 0 ]
alter @vw1[pwl] = [ 0 1 1 1 ]
alter @vw2[pwl] = [ 0 0 1 0 ]
alter rload = 100k
alter rsrc = 1.5
ac dec 50 10 20k
let rdb = vdb(jack)
meas ac r20 find rdb at=20
meas ac r1k find rdb at=1000
let e9 = r20 - r1k
echo "3,ct10u,10,1,100k,e9_db,$&e9" >> /Users/roberto/EDA/.claude/worktrees/L48b/docs/preamp/data/2026-10-07/L48b/scatti/ac/ac_rumore.csv
destroy all
alter rload = 10k
alter rsrc = 1.5
ac dec 50 10 20k
let rdb = vdb(jack)
meas ac r20 find rdb at=20
meas ac r1k find rdb at=1000
let e9 = r20 - r1k
echo "3,ct10u,10,1,10k,e9_db,$&e9" >> /Users/roberto/EDA/.claude/worktrees/L48b/docs/preamp/data/2026-10-07/L48b/scatti/ac/ac_rumore.csv
destroy all
alter rload = 100k
alter rsrc = 1.5
noise v(jack) vsrc dec 50 20 20000 1
setplot noise2
let onu = onoise_total*1e6
echo "3,ct10u,10,1,1.5,e5_uv,$&onu" >> /Users/roberto/EDA/.claude/worktrees/L48b/docs/preamp/data/2026-10-07/L48b/scatti/ac/ac_rumore.csv
destroy all
alter rsrc = 430
noise v(jack) vsrc dec 50 20 20000 1
setplot noise2
let onu = onoise_total*1e6
echo "3,ct10u,10,1,430,e5_uv,$&onu" >> /Users/roberto/EDA/.claude/worktrees/L48b/docs/preamp/data/2026-10-07/L48b/scatti/ac/ac_rumore.csv
destroy all
alter rsrc = 1.5
* ---- ac ct10u g=10 att=2
alter ca = 1p
alter rbya = 1m
alter ctx = 10u
alter rbyt = 1e12
alter cb = 1p
alter rbyb = 1m
alter rgate = 1e12
alter rbal = 1e12
alter vosa dc = 0
alter iosa dc = 0
alter rrgb = 0.1
alter rrg10b = 0.1
alter ra = 5000
alter rb = 0.001
alter rc = 5000
alter @vt1r[pwl] = [ 0 1 1 1 ]
alter @vt1s[pwl] = [ 0 0 1 0 ]
alter @vt2r[pwl] = [ 0 1 1 1 ]
alter @vt2s[pwl] = [ 0 0 1 0 ]
alter @vw1[pwl] = [ 0 1 1 1 ]
alter @vw2[pwl] = [ 0 0 1 0 ]
alter rload = 100k
alter rsrc = 1.5
ac dec 50 10 20k
let rdb = vdb(jack)
meas ac r20 find rdb at=20
meas ac r1k find rdb at=1000
let e9 = r20 - r1k
echo "3,ct10u,10,2,100k,e9_db,$&e9" >> /Users/roberto/EDA/.claude/worktrees/L48b/docs/preamp/data/2026-10-07/L48b/scatti/ac/ac_rumore.csv
destroy all
alter rload = 10k
alter rsrc = 1.5
ac dec 50 10 20k
let rdb = vdb(jack)
meas ac r20 find rdb at=20
meas ac r1k find rdb at=1000
let e9 = r20 - r1k
echo "3,ct10u,10,2,10k,e9_db,$&e9" >> /Users/roberto/EDA/.claude/worktrees/L48b/docs/preamp/data/2026-10-07/L48b/scatti/ac/ac_rumore.csv
destroy all
alter rload = 100k
alter rsrc = 1.5
noise v(jack) vsrc dec 50 20 20000 1
setplot noise2
let onu = onoise_total*1e6
echo "3,ct10u,10,2,1.5,e5_uv,$&onu" >> /Users/roberto/EDA/.claude/worktrees/L48b/docs/preamp/data/2026-10-07/L48b/scatti/ac/ac_rumore.csv
destroy all
alter rsrc = 430
noise v(jack) vsrc dec 50 20 20000 1
setplot noise2
let onu = onoise_total*1e6
echo "3,ct10u,10,2,430,e5_uv,$&onu" >> /Users/roberto/EDA/.claude/worktrees/L48b/docs/preamp/data/2026-10-07/L48b/scatti/ac/ac_rumore.csv
destroy all
alter rsrc = 1.5
* ---- ac finale g=0 att=1
alter ca = 1p
alter rbya = 1m
alter ctx = 10u
alter rbyt = 1e12
alter cb = 1p
alter rbyb = 1m
alter rgate = 1Meg
alter rbal = 50k
alter vosa dc = 0
alter iosa dc = 0
alter rrgb = 1e+09
alter rrg10b = 1e+09
alter ra = 0.001
alter rb = 2057
alter rc = 7943
alter @vt1r[pwl] = [ 0 1 1 1 ]
alter @vt1s[pwl] = [ 0 0 1 0 ]
alter @vt2r[pwl] = [ 0 1 1 1 ]
alter @vt2s[pwl] = [ 0 0 1 0 ]
alter @vw1[pwl] = [ 0 1 1 1 ]
alter @vw2[pwl] = [ 0 0 1 0 ]
alter rload = 100k
alter rsrc = 1.5
ac dec 50 10 20k
let rdb = vdb(jack)
meas ac r20 find rdb at=20
meas ac r1k find rdb at=1000
let e9 = r20 - r1k
echo "4,finale,0,1,100k,e9_db,$&e9" >> /Users/roberto/EDA/.claude/worktrees/L48b/docs/preamp/data/2026-10-07/L48b/scatti/ac/ac_rumore.csv
destroy all
alter rload = 10k
alter rsrc = 1.5
ac dec 50 10 20k
let rdb = vdb(jack)
meas ac r20 find rdb at=20
meas ac r1k find rdb at=1000
let e9 = r20 - r1k
echo "4,finale,0,1,10k,e9_db,$&e9" >> /Users/roberto/EDA/.claude/worktrees/L48b/docs/preamp/data/2026-10-07/L48b/scatti/ac/ac_rumore.csv
destroy all
alter rload = 100k
alter rsrc = 1.5
noise v(jack) vsrc dec 50 20 20000 1
setplot noise2
let onu = onoise_total*1e6
echo "4,finale,0,1,1.5,e5_uv,$&onu" >> /Users/roberto/EDA/.claude/worktrees/L48b/docs/preamp/data/2026-10-07/L48b/scatti/ac/ac_rumore.csv
destroy all
alter rsrc = 430
noise v(jack) vsrc dec 50 20 20000 1
setplot noise2
let onu = onoise_total*1e6
echo "4,finale,0,1,430,e5_uv,$&onu" >> /Users/roberto/EDA/.claude/worktrees/L48b/docs/preamp/data/2026-10-07/L48b/scatti/ac/ac_rumore.csv
destroy all
alter rsrc = 1.5
* ---- ac finale g=0 att=2
alter ca = 1p
alter rbya = 1m
alter ctx = 10u
alter rbyt = 1e12
alter cb = 1p
alter rbyb = 1m
alter rgate = 1Meg
alter rbal = 50k
alter vosa dc = 0
alter iosa dc = 0
alter rrgb = 1e+09
alter rrg10b = 1e+09
alter ra = 5000
alter rb = 0.001
alter rc = 5000
alter @vt1r[pwl] = [ 0 1 1 1 ]
alter @vt1s[pwl] = [ 0 0 1 0 ]
alter @vt2r[pwl] = [ 0 1 1 1 ]
alter @vt2s[pwl] = [ 0 0 1 0 ]
alter @vw1[pwl] = [ 0 1 1 1 ]
alter @vw2[pwl] = [ 0 0 1 0 ]
alter rload = 100k
alter rsrc = 1.5
ac dec 50 10 20k
let rdb = vdb(jack)
meas ac r20 find rdb at=20
meas ac r1k find rdb at=1000
let e9 = r20 - r1k
echo "4,finale,0,2,100k,e9_db,$&e9" >> /Users/roberto/EDA/.claude/worktrees/L48b/docs/preamp/data/2026-10-07/L48b/scatti/ac/ac_rumore.csv
destroy all
alter rload = 10k
alter rsrc = 1.5
ac dec 50 10 20k
let rdb = vdb(jack)
meas ac r20 find rdb at=20
meas ac r1k find rdb at=1000
let e9 = r20 - r1k
echo "4,finale,0,2,10k,e9_db,$&e9" >> /Users/roberto/EDA/.claude/worktrees/L48b/docs/preamp/data/2026-10-07/L48b/scatti/ac/ac_rumore.csv
destroy all
alter rload = 100k
alter rsrc = 1.5
noise v(jack) vsrc dec 50 20 20000 1
setplot noise2
let onu = onoise_total*1e6
echo "4,finale,0,2,1.5,e5_uv,$&onu" >> /Users/roberto/EDA/.claude/worktrees/L48b/docs/preamp/data/2026-10-07/L48b/scatti/ac/ac_rumore.csv
destroy all
alter rsrc = 430
noise v(jack) vsrc dec 50 20 20000 1
setplot noise2
let onu = onoise_total*1e6
echo "4,finale,0,2,430,e5_uv,$&onu" >> /Users/roberto/EDA/.claude/worktrees/L48b/docs/preamp/data/2026-10-07/L48b/scatti/ac/ac_rumore.csv
destroy all
alter rsrc = 1.5
* ---- ac finale g=10 att=1
alter ca = 1p
alter rbya = 1m
alter ctx = 10u
alter rbyt = 1e12
alter cb = 1p
alter rbyb = 1m
alter rgate = 1Meg
alter rbal = 50k
alter vosa dc = 0
alter iosa dc = 0
alter rrgb = 0.1
alter rrg10b = 0.1
alter ra = 0.001
alter rb = 2057
alter rc = 7943
alter @vt1r[pwl] = [ 0 1 1 1 ]
alter @vt1s[pwl] = [ 0 0 1 0 ]
alter @vt2r[pwl] = [ 0 1 1 1 ]
alter @vt2s[pwl] = [ 0 0 1 0 ]
alter @vw1[pwl] = [ 0 1 1 1 ]
alter @vw2[pwl] = [ 0 0 1 0 ]
alter rload = 100k
alter rsrc = 1.5
ac dec 50 10 20k
let rdb = vdb(jack)
meas ac r20 find rdb at=20
meas ac r1k find rdb at=1000
let e9 = r20 - r1k
echo "4,finale,10,1,100k,e9_db,$&e9" >> /Users/roberto/EDA/.claude/worktrees/L48b/docs/preamp/data/2026-10-07/L48b/scatti/ac/ac_rumore.csv
destroy all
alter rload = 10k
alter rsrc = 1.5
ac dec 50 10 20k
let rdb = vdb(jack)
meas ac r20 find rdb at=20
meas ac r1k find rdb at=1000
let e9 = r20 - r1k
echo "4,finale,10,1,10k,e9_db,$&e9" >> /Users/roberto/EDA/.claude/worktrees/L48b/docs/preamp/data/2026-10-07/L48b/scatti/ac/ac_rumore.csv
destroy all
alter rload = 100k
alter rsrc = 1.5
noise v(jack) vsrc dec 50 20 20000 1
setplot noise2
let onu = onoise_total*1e6
echo "4,finale,10,1,1.5,e5_uv,$&onu" >> /Users/roberto/EDA/.claude/worktrees/L48b/docs/preamp/data/2026-10-07/L48b/scatti/ac/ac_rumore.csv
destroy all
alter rsrc = 430
noise v(jack) vsrc dec 50 20 20000 1
setplot noise2
let onu = onoise_total*1e6
echo "4,finale,10,1,430,e5_uv,$&onu" >> /Users/roberto/EDA/.claude/worktrees/L48b/docs/preamp/data/2026-10-07/L48b/scatti/ac/ac_rumore.csv
destroy all
alter rsrc = 1.5
* ---- ac finale g=10 att=2
alter ca = 1p
alter rbya = 1m
alter ctx = 10u
alter rbyt = 1e12
alter cb = 1p
alter rbyb = 1m
alter rgate = 1Meg
alter rbal = 50k
alter vosa dc = 0
alter iosa dc = 0
alter rrgb = 0.1
alter rrg10b = 0.1
alter ra = 5000
alter rb = 0.001
alter rc = 5000
alter @vt1r[pwl] = [ 0 1 1 1 ]
alter @vt1s[pwl] = [ 0 0 1 0 ]
alter @vt2r[pwl] = [ 0 1 1 1 ]
alter @vt2s[pwl] = [ 0 0 1 0 ]
alter @vw1[pwl] = [ 0 1 1 1 ]
alter @vw2[pwl] = [ 0 0 1 0 ]
alter rload = 100k
alter rsrc = 1.5
ac dec 50 10 20k
let rdb = vdb(jack)
meas ac r20 find rdb at=20
meas ac r1k find rdb at=1000
let e9 = r20 - r1k
echo "4,finale,10,2,100k,e9_db,$&e9" >> /Users/roberto/EDA/.claude/worktrees/L48b/docs/preamp/data/2026-10-07/L48b/scatti/ac/ac_rumore.csv
destroy all
alter rload = 10k
alter rsrc = 1.5
ac dec 50 10 20k
let rdb = vdb(jack)
meas ac r20 find rdb at=20
meas ac r1k find rdb at=1000
let e9 = r20 - r1k
echo "4,finale,10,2,10k,e9_db,$&e9" >> /Users/roberto/EDA/.claude/worktrees/L48b/docs/preamp/data/2026-10-07/L48b/scatti/ac/ac_rumore.csv
destroy all
alter rload = 100k
alter rsrc = 1.5
noise v(jack) vsrc dec 50 20 20000 1
setplot noise2
let onu = onoise_total*1e6
echo "4,finale,10,2,1.5,e5_uv,$&onu" >> /Users/roberto/EDA/.claude/worktrees/L48b/docs/preamp/data/2026-10-07/L48b/scatti/ac/ac_rumore.csv
destroy all
alter rsrc = 430
noise v(jack) vsrc dec 50 20 20000 1
setplot noise2
let onu = onoise_total*1e6
echo "4,finale,10,2,430,e5_uv,$&onu" >> /Users/roberto/EDA/.claude/worktrees/L48b/docs/preamp/data/2026-10-07/L48b/scatti/ac/ac_rumore.csv
destroy all
alter rsrc = 1.5
quit
.endc

.end
