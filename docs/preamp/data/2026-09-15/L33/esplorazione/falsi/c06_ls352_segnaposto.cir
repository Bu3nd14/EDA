tb_op.cir - gain block operating point, BLOCK B wired as the output stage
* First line is a title (docs/limitations.md #10). Do not put a directive here.
* Models are PLACEHOLDERS: DC bias is credible, distortion is not.

* ---------------------------------------------------------------------
* CONVENZIONE DI PERCORSO (collaudata su questo deck in L2; L3 la replica
* sugli altri 11 senza riprogettarla). Due regole, una per meta'.
*
* LETTURA - `.include @REPO@/<percorso-dalla-radice-del-repo>`.
*   run_simulation.sh sostituisce @REPO@ con la radice del checkout di
*   cui lo script stesso fa parte, e scrive un deck derivato
*   <nome>_resolved.cir dentro la directory dei risultati.
*
*   Perche' non un percorso relativo: ngspice risolve un `.include`
*   relativo contro la DIRECTORY DI LAVORO, non contro la directory del
*   deck - e run_simulation.sh fa `cd "$OUTDIR"` prima di lanciare
*   ngspice. Verificato, non dedotto: due file entrambi chiamati
*   ../real.lib, uno raggiungibile dalla directory del deck (1 kohm) e
*   uno dal cwd (9 kohm); ngspice -b ha letto quello del cwd
*   (i(V1) = -1.111e-04 = 1/9k contro -1.000e-03 = 1/1k).
*
*   Un @REPO@ non sostituito fallisce in modo rumoroso: ngspice esce 1
*   con "Could not find include file". Non e' un fallimento silenzioso.
*
* SCRITTURA - `wrdata <nome-nudo>`, senza alcun percorso.
*   Lo stesso `cd "$OUTDIR"` lo fa atterrare nella directory dei
*   risultati da solo. Il nome <basename-del-deck>_wrdata.txt e' quello
*   che run_simulation.sh cerca per PRIMO (righe 80-90): usarlo evita il
*   fallback che fa `grep ... | head -1`.
*
*   Nota per L3/L5: un deck con PIU' di un `wrdata` (tb_dc_headroom.cir
*   ne ha 2) non puo' usare quel nome per entrambi e cade sul fallback,
*   che ne vede solo il primo. Va gestito, non ereditato per distrazione.
* ---------------------------------------------------------------------

.include @REPO@/spice/preamp/placeholder_devices.lib
* L22: the input current mirror is no longer a placeholder. It is an
* LS352 (ADR-018) and this is still a placeholder - the only one in this
* deck. L33 (NC-031): the LSK489 is not a vendor model here. Its halves
* are LSK489X, a hand-written placeholder with KF=0; the vendor model
* models/jfet/lsk489.lib is included by no deck (Fase 4, NC-017). Every
* OTHER device here is a hand-written placeholder too, and none has 1/f.
.include @REPO@/models/bjt_pnp/ls350.lib
.include @REPO@/spice/preamp/gain_block_flat.inc

VPP VPLUS 0 DC 15
VMM VMINUS 0 DC -15
VIN IN 0 DC 0 AC 1

* Gain relay: open contact = 0 dB. An open relay contact is not an infinite
* impedance, it is ~15 pF of stray with a very large leakage resistance.
CSTRAY RG 0 15p
CSTRAY10 RG10 0 15p
RLEAK  RG 0 1G
RLEAK10 RG10 0 1G

* Output network of BLOCK B (main output), per E8 / ADR-007:
RISO  OUT OUTA 47
COUT  OUTA JACK 4.7u
RBLEED JACK 0 220k
RLOAD JACK 0 100k

.control
op
* Meta' scrittura della convenzione: nome nudo, nessun percorso.
wrdata tb_op_wrdata.txt v(OUT) v(JACK) v(FB) v(SRC) i(VPP) i(VMM)
echo "=== NODE VOLTAGES ==="
print v(IN) v(FB) v(OUT) v(JACK) v(NREF) v(NREFM) v(NCASC) v(SRC)
print v(G1) v(G2) v(S1) v(S2) v(D1N) v(D2N) v(NMIRI) v(NHI)
print v(NX) v(NY) v(NBB) v(NBN) v(NBP) v(NEN) v(NEP) v(NVE) v(NVLE) v(NTE)
echo "=== INPUT JFET PAIR (LSK489 halves) ==="
print @jq110a[id]
print @jq110b[id]
print @jq110a[vgs]
print @jq110b[vgs]
print @jq110a[gm]
print @jq110b[gm]
echo "=== RAIL CURRENTS (A) ==="
print i(VPP) i(VMM)
echo "=== BJT OPERATING POINTS: ic / vce ==="
print @q106[ic] @q106[ib] @q106[vbe] @q106[vbc]
print @q117[ic] @q117[ib] @q117[vbe] @q117[vbc]
print @q118[ic] @q118[ib] @q118[vbe] @q118[vbc]
print @q121A[ic] @q121A[ib] @q121A[vbe] @q121A[vbc]
print @q121B[ic] @q121B[ib] @q121B[vbe] @q121B[vbc]
print @q122[ic] @q122[ib] @q122[vbe] @q122[vbc]
print @q125[ic] @q125[ib] @q125[vbe] @q125[vbc]
print @q127[ic] @q127[ib] @q127[vbe] @q127[vbc]
print @q132[ic] @q132[ib] @q132[vbe] @q132[vbc]
print @q133[ic] @q133[ib] @q133[vbe] @q133[vbc]
echo "=== KEY BRANCH CURRENTS ==="
print @riso[i] @r136[i] @r134[i] @r135[i] @r107[i] @r123[i] @r126[i]
.endc

.end
