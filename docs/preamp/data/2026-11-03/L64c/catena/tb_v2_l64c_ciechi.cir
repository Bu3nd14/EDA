tb_v2_casopeggiore.cir - V2 al jack, il caso peggiore col mute che taglia coi soli rele' al jack (ADR-062): guadagno, trim, dispersione, durata del mute, accensione (L29c, NC-028, L47c2b1)
* Prima riga = titolo (docs/limitations.md #10).
* GENERATO da docs/preamp/data/2026-09-23/L29c/deck/genera_tb_v2_casopeggiore.py: non si
* edita a mano. L'intestazione del generatore dice cosa c'e' dentro, le ipotesi di
* accensione e spegnimento, e come si corre. Matrice: l41c.
* MATRICE sorgente (L29e, ADR-044): il mute al jack e' la geometria iii com'e' in
* circuits/preamp/preamp_audio.net - un deviatore per uscita, COM al lato del condensatore,
* NC a massa, NO al jack. Il generatore la LEGGE dalla netlist col controllo del 2e e rifiuta
* se non c'e'; i bleed lato condensatore (rbcm/rbc1/rbc2) sono i valori della netlist, il
* bleed del jack deve coincidere con RBLx del blocco. Dal banco restano: il contatto aperto
* 0,1 pF (datasheet, L29d2), il trasferimento 1 ms (ipotesi) e 0 pF di cavo (caso peggiore).
* Nomi e righe sono quelli di L29d2 (suffisso _iii), variante di progetto.
*
* NIENTE FOTORESISTENZE (ADR-062, L47c2b1): la sorgente arriva al blocco A dalla sua RSRC,
* come nella cella di L40. Ogni dispositivo attivo e' il modello del
* costruttore in models/ (L39); nessuno porta la dispersione, che qui si inietta: VOS* e
* `altermod lsk489a vto` (gruppo B, ADR-031). UN MODELLO ALTERATO PORTA ANCORA IL NOME
* LSK489A (limitations #29): le corse alterate lo dicono nel nome (_gb*) e stampano showmod
* e la corrente della sonda JPRB.
*
* IL MUTE TAGLIA: il contatto in serie al jack si apre 24 ms dopo il tasto (MUTE_CMD 21 ms,
* firmware di L47c2a, piu' 3 ms del G6K), la derivazione 1 ms dopo; al rilascio lo stesso.
* t_ins e t_rel del manifesto sono gli istanti del tasto.
* ANALISI: scripts/v2_metodo.py analizza sul manifesto; le colonne gruppo e conta dicono
* quali grandezze di ogni riga sono verdetto. Si corre DIVISO (dividi.py): le corse di
* accensione alterano le sorgenti dei rail, e in sequenza l'alterazione resterebbe.
* CONVENZIONE DI PERCORSO: `.include @REPO@/...` (tb_op.cir, L2-L3).

.include @REPO@/models/jfet/lsk489.lib
.include @REPO@/models/bjt_npn/mmbt5551.lib
.include @REPO@/models/bjt_pnp/mmbt5401.lib
.include @REPO@/models/bjt_npn/mje15032.lib
.include @REPO@/models/bjt_pnp/mje15033.lib
.include @REPO@/models/diodes/1n4148.lib
.include @REPO@/models/bjt_pnp/ls350.lib
.include @REPO@/spice/preamp/gain_block.subckt

* >>> CANALE - identico nei tre deck tb_v2_mute_*.cir (v2_metodo.py canale)
* TOLLERANZE (L29a, ripresa 2026-09-16): vedi il blocco esteso in
* tb_v2_mute_varianti.cir. vntol=1e-9 rendeva il deck non eseguibile (41 ore
* per una cella senza segnale); vntol=1e-6 la fa in 5,5 s e le cifre non
* cambiano - verificato, data/2026-09-16/L29a/tolleranze/.
.options reltol=1e-6 vntol=1e-6 abstol=1e-12
VPP VPLUS 0 DC 15
VMM VMINUS 0 DC -15

* ---- sorgente con inviluppo d'entrata ----
VAMP NAMP 0 DC 3.818
VFRQ NFRQ 0 DC 1000
VPHS NPHS 0 DC 0
VTEN NTEN 0 DC 0.3
BSRC SRC 0 V = V(NAMP) * sin(6.283185307179586*V(NFRQ)*time + V(NPHS))
+ * (0.5 - 0.5*cos(3.141592653589793*min(time/V(NTEN), 1)))
RSRC SRC SELA 1.5

* ---- stati dei contatti: t_ins, t_rel, durata graduale, netto(1)/graduale(0) ----
VTIJK NTIJK 0 DC 1000
VTRJK NTRJK 0 DC 2000
VTGJK NTGJK 0 DC 1
VMHJK NMHJK 0 DC 1
BSJKR SJKR 0 V = V(NMHJK)
+ * pwl(time - V(NTIJK), -1e4,0, 0,0, 1u,1, 150u,1, 151u,0, 300u,0, 301u,1, 450u,1, 451u,0, 520u,0, 521u,1, 1e4,1)
+ * pwl(time - V(NTRJK), -1e4,1, 0,1, 1u,0, 400u,0, 401u,1, 600u,1, 601u,0, 1e4,0)
+ + (1 - V(NMHJK)) * min(max((time - V(NTIJK))/V(NTGJK), 0), 1)
+ * (1 - min(max((time - V(NTRJK))/V(NTGJK), 0), 1))
RSJK SJKR SJK 1k
CSJK SJK 0 4.55n
VTIPRE NTIPRE 0 DC 1000
VTRPRE NTRPRE 0 DC 2000
VTGPRE NTGPRE 0 DC 1
VMHPRE NMHPRE 0 DC 1
BSPRER SPRER 0 V = V(NMHPRE)
+ * pwl(time - V(NTIPRE), -1e4,0, 0,0, 1u,1, 150u,1, 151u,0, 300u,0, 301u,1, 450u,1, 451u,0, 520u,0, 521u,1, 1e4,1)
+ * pwl(time - V(NTRPRE), -1e4,1, 0,1, 1u,0, 400u,0, 401u,1, 600u,1, 601u,0, 1e4,0)
+ + (1 - V(NMHPRE)) * min(max((time - V(NTIPRE))/V(NTGPRE), 0), 1)
+ * (1 - min(max((time - V(NTRPRE))/V(NTGPRE), 0), 1))
RSPRE SPRER SPRE 1k
CSPRE SPRE 0 4.55n
VTISER NTISER 0 DC 1000
VTRSER NTRSER 0 DC 2000
VTGSER NTGSER 0 DC 1
VMHSER NMHSER 0 DC 1
BSSERR SSERR 0 V = V(NMHSER)
+ * pwl(time - V(NTISER), -1e4,0, 0,0, 1u,1, 150u,1, 151u,0, 300u,0, 301u,1, 450u,1, 451u,0, 520u,0, 521u,1, 1e4,1)
+ * pwl(time - V(NTRSER), -1e4,1, 0,1, 1u,0, 400u,0, 401u,1, 600u,1, 601u,0, 1e4,0)
+ + (1 - V(NMHSER)) * min(max((time - V(NTISER))/V(NTGSER), 0), 1)
+ * (1 - min(max((time - V(NTRSER))/V(NTGSER), 0), 1))
RSSER SSERR SSER 1k
CSSER SSER 0 4.55n
VTISEL NTISEL 0 DC 1000
VTRSEL NTRSEL 0 DC 2000
VTGSEL NTGSEL 0 DC 1
VMHSEL NMHSEL 0 DC 1
BSSELR SSELR 0 V = V(NMHSEL)
+ * pwl(time - V(NTISEL), -1e4,0, 0,0, 1u,1, 150u,1, 151u,0, 300u,0, 301u,1, 450u,1, 451u,0, 520u,0, 521u,1, 1e4,1)
+ * pwl(time - V(NTRSEL), -1e4,1, 0,1, 1u,0, 400u,0, 401u,1, 600u,1, 601u,0, 1e4,0)
+ + (1 - V(NMHSEL)) * min(max((time - V(NTISEL))/V(NTGSEL), 0), 1)
+ * (1 - min(max((time - V(NTRSEL))/V(NTGSEL), 0), 1))
RSSEL SSELR SSEL 1k
CSSEL SSEL 0 4.55n

* ---- selettore d'ingresso: serie, s = 1 vuol dire APERTO ----
BSEL SELA INA I = V(SELA,INA) * pow(10, -12 + 13*(1 - V(SSEL)))

* ---------------- BLOCCO A: guadagno 1, R_g non montata ------------------
VOSA INA INAX DC 0
XA INAX OUTA FBA RGA RG10A VPLUS VMINUS GAINBLOCK
RRGA RGA 0 1G
CRGA RGA 0 15p
RRG10A RG10A 0 1G
CRG10A RG10A 0 15p

* Attenuatore da 10 k: RATTT a 1 mohm = manopola al massimo.
RATTT OUTA W 1m
RATTB W 0 10k

* ---------------- BUFFER DELLE FISSE (ADR-023): guadagno 1 ---------------
VOSF1 OUTA F1IN DC 0
XF1 F1IN OUTF1 FBF1 RGF1 RG10F1 VPLUS VMINUS GAINBLOCK
RRGF1 RGF1 0 1G
CRGF1 RGF1 0 15p
RRG10F1 RG10F1 0 1G
CRG10F1 RG10F1 0 15p
VOSF2 OUTA F2IN DC 0
XF2 F2IN OUTF2 FBF2 RGF2 RG10F2 VPLUS VMINUS GAINBLOCK
RRGF2 RGF2 0 1G
CRGF2 RGF2 0 15p
RRG10F2 RG10F2 0 1G
CRG10F2 RG10F2 0 15p

RSEP1 OUTF1 FIX1 47
BPRE1 FIX1 0 I = V(FIX1) * pow(10, -12 + 13*V(SPRE))
CFIX1 FIX1 FIXC1 4.7u
RBC1 FIXC1 0 1e12
RBY1 FIXC1 FIXJACK1 1m
BSER1 FIXC1 FIXJACK1 I = V(FIXC1,FIXJACK1) * pow(10, -12 + 13*(1 - V(SSER)))
BJK1 FIXJACK1 0 I = V(FIXJACK1) * pow(10, -12 + 13*V(SJK))
RBL1 FIXJACK1 0 470k
RLD1 FIXJACK1 0 100k

RSEP2 OUTF2 FIX2 47
BPRE2 FIX2 0 I = V(FIX2) * pow(10, -12 + 13*V(SPRE))
CFIX2 FIX2 FIXC2 4.7u
RBC2 FIXC2 0 1e12
RBY2 FIXC2 FIXJACK2 1m
BSER2 FIXC2 FIXJACK2 I = V(FIXC2,FIXJACK2) * pow(10, -12 + 13*(1 - V(SSER)))
BJK2 FIXJACK2 0 I = V(FIXJACK2) * pow(10, -12 + 13*V(SJK))
RBL2 FIXJACK2 0 470k
RLD2 FIXJACK2 0 100k

* ---------------- BLOCCO B: 0 / +3 / +10 dB, due rele' su R_g ------------
* Contatto aperto = 1 G + 15 pF, chiuso = alter ... = 0.1 (ADR-026):
*   0 dB   rrgb = 1G    rrg10b = 1G
*   +3 dB  rrgb = 0.1   rrg10b = 1G
*   +10 dB rrgb = 0.1   rrg10b = 0.1
VOSB W WB DC 0
XB WB OUTB FBB RGB RG10B VPLUS VMINUS GAINBLOCK
RRGB RGB 0 1G
CRGB RGB 0 15p
RRG10B RG10B 0 1G
CRG10B RG10B 0 15p
RISOM OUTB MAIN_A 47
BPREM MAIN_A 0 I = V(MAIN_A) * pow(10, -12 + 13*V(SPRE))
COUTM MAIN_A MAINC 4.7u
RBCM MAINC 0 1e12
RBYM MAINC MAINJACK 1m
BSERM MAINC MAINJACK I = V(MAINC,MAINJACK) * pow(10, -12 + 13*(1 - V(SSER)))
BJKM MAINJACK 0 I = V(MAINJACK) * pow(10, -12 + 13*V(SJK))
RBLM MAINJACK 0 220k
RLDM MAINJACK 0 100k
* <<< CANALE
* ---- L47b2b1: IOSA fornisce a R113 (dentro il blocco A) la corrente dovuta a VOSA, che
* nel circuito non passa nella rete d'ingresso: vedi iosa() nel generatore, limitations #44 ----
IOSA INAX 0 DC 0

* ---- L29c: i contatti del guadagno, in parallelo a RRGB / RRG10B del blocco ----
* interruttore nativo: 0,1 ohm chiuso (il massimo del G6K), 1 T aperto; soglia 0,5 V sulla
* pwl 0/1 dei rimbalzi, isteresi 0,25 V
.model SWK SW(RON=0.1 ROFF=1e12 VT=0.5 VH=0.25)
VK1I NK1I 0 DC 0
VK1T NK1T 0 DC 1000
BK1R SK1R 0 V = (1 - V(NK1I)) * pwl(time - V(NK1T), -1e4,0, 0,0, 1u,1, 150u,1, 151u,0, 300u,0, 301u,1, 450u,1, 451u,0, 520u,0, 521u,1, 1e4,1)
+ + V(NK1I) * pwl(time - V(NK1T), -1e4,1, 0,1, 1u,0, 400u,0, 401u,1, 600u,1, 601u,0, 1e4,0)
SK1 RGB 0 SK1R 0 SWK
VK5I NK5I 0 DC 0
VK5T NK5T 0 DC 1000
BK5R SK5R 0 V = (1 - V(NK5I)) * pwl(time - V(NK5T), -1e4,0, 0,0, 1u,1, 150u,1, 151u,0, 300u,0, 301u,1, 450u,1, 451u,0, 520u,0, 521u,1, 1e4,1)
+ + V(NK5I) * pwl(time - V(NK5T), -1e4,1, 0,1, 1u,0, 400u,0, 401u,1, 600u,1, 601u,0, 1e4,0)
SK5 RG10B 0 SK5R 0 SWK
VK1BI NK1BI 0 DC 0
VK1BT NK1BT 0 DC 1000
BK1BR SK1BR 0 V = (1 - V(NK1BI)) * pwl(time - V(NK1BT), -1e4,0, 0,0, 1u,1, 150u,1, 151u,0, 300u,0, 301u,1, 450u,1, 451u,0, 520u,0, 521u,1, 1e4,1)
+ + V(NK1BI) * pwl(time - V(NK1BT), -1e4,1, 0,1, 1u,0, 400u,0, 401u,1, 600u,1, 601u,0, 1e4,0)
RK1BS SK1BR SK1B 1k
CK1BS SK1B 0 4.55n
BK1B RGB 0 I = V(RGB) * pow(10, -12 + 13*V(SK1B))
VK5BI NK5BI 0 DC 0
VK5BT NK5BT 0 DC 1000
BK5BR SK5BR 0 V = (1 - V(NK5BI)) * pwl(time - V(NK5BT), -1e4,0, 0,0, 1u,1, 150u,1, 151u,0, 300u,0, 301u,1, 450u,1, 451u,0, 520u,0, 521u,1, 1e4,1)
+ + V(NK5BI) * pwl(time - V(NK5BT), -1e4,1, 0,1, 1u,0, 400u,0, 401u,1, 600u,1, 601u,0, 1e4,0)
RK5BS SK5BR SK5B 1k
CK5BS SK5B 0 4.55n
BK5B RG10B 0 I = V(RG10B) * pow(10, -12 + 13*V(SK5B))
* ---- L29d: il contatto in serie al jack e la derivazione lato condensatore ----
VKSA NKSA 0 DC 1000
VKSB NKSB 0 DC 2000
BKSR NKSR 0 V = pwl(time - V(NKSA), -1e4,1, 0,1, 1u,0, 400u,0, 401u,1, 600u,1, 601u,0, 1e4,0) + pwl(time - V(NKSB), -1e4,0, 0,0, 1u,1, 150u,1, 151u,0, 300u,0, 301u,1, 450u,1, 451u,0, 520u,0, 521u,1, 1e4,1)
VKCA NKCA 0 DC 1000
VKCB NKCB 0 DC 2000
BKCR NKCR 0 V = pwl(time - V(NKCA), -1e4,0, 0,0, 1u,1, 150u,1, 151u,0, 300u,0, 301u,1, 450u,1, 451u,0, 520u,0, 521u,1, 1e4,1) + pwl(time - V(NKCB), -1e4,1, 0,1, 1u,0, 400u,0, 401u,1, 600u,1, 601u,0, 1e4,0) - 1
SKSM MAINC MAINJACK NKSR 0 SWK
CKSM MAINC MAINJACK 0.1p
SKCM MAINC 0 NKCR 0 SWK
CCAVM MAINJACK 0 1e-18
SKS1 FIXC1 FIXJACK1 NKSR 0 SWK
CKS1 FIXC1 FIXJACK1 0.1p
SKC1 FIXC1 0 NKCR 0 SWK
CCAV1 FIXJACK1 0 1e-18
SKS2 FIXC2 FIXJACK2 NKSR 0 SWK
CKS2 FIXC2 FIXJACK2 0.1p
SKC2 FIXC2 0 NKCR 0 SWK
CCAV2 FIXJACK2 0 1e-18

* ---- L29c: il trim (ADR-027, trim.py candidato 2) fra OUTA e l'attenuatore ----
* RATTT del blocco si apre nel .control (alter rattt = 1e12): OUTA arriva a W da qui.
RL1 OUTA TAP6 845
RL2 TAP6 TAP12 464
RL3 TAP12 0 464
VT1RI NT1RI 0 DC 0
VT1RT NT1RT 0 DC 1000
BT1RR ST1RR 0 V = (1 - V(NT1RI)) * pwl(time - V(NT1RT), -1e4,0, 0,0, 1u,1, 150u,1, 151u,0, 300u,0, 301u,1, 450u,1, 451u,0, 520u,0, 521u,1, 1e4,1)
+ + V(NT1RI) * pwl(time - V(NT1RT), -1e4,1, 0,1, 1u,0, 400u,0, 401u,1, 600u,1, 601u,0, 1e4,0)
ST1R OUTA ATOP ST1RR 0 SWK
CT1RP OUTA ATOP 15p
RT1RP OUTA ATOP 1G
VT1SI NT1SI 0 DC 0
VT1ST NT1ST 0 DC 1000
BT1SR ST1SR 0 V = (1 - V(NT1SI)) * pwl(time - V(NT1ST), -1e4,0, 0,0, 1u,1, 150u,1, 151u,0, 300u,0, 301u,1, 450u,1, 451u,0, 520u,0, 521u,1, 1e4,1)
+ + V(NT1SI) * pwl(time - V(NT1ST), -1e4,1, 0,1, 1u,0, 400u,0, 401u,1, 600u,1, 601u,0, 1e4,0)
ST1S T2C ATOP ST1SR 0 SWK
CT1SP T2C ATOP 15p
RT1SP T2C ATOP 1G
VT2RI NT2RI 0 DC 0
VT2RT NT2RT 0 DC 1000
BT2RR ST2RR 0 V = (1 - V(NT2RI)) * pwl(time - V(NT2RT), -1e4,0, 0,0, 1u,1, 150u,1, 151u,0, 300u,0, 301u,1, 450u,1, 451u,0, 520u,0, 521u,1, 1e4,1)
+ + V(NT2RI) * pwl(time - V(NT2RT), -1e4,1, 0,1, 1u,0, 400u,0, 401u,1, 600u,1, 601u,0, 1e4,0)
ST2R TAP6 T2C ST2RR 0 SWK
CT2RP TAP6 T2C 15p
RT2RP TAP6 T2C 1G
VT2SI NT2SI 0 DC 0
VT2ST NT2ST 0 DC 1000
BT2SR ST2SR 0 V = (1 - V(NT2SI)) * pwl(time - V(NT2ST), -1e4,0, 0,0, 1u,1, 150u,1, 151u,0, 300u,0, 301u,1, 450u,1, 451u,0, 520u,0, 521u,1, 1e4,1)
+ + V(NT2SI) * pwl(time - V(NT2ST), -1e4,1, 0,1, 1u,0, 400u,0, 401u,1, 600u,1, 601u,0, 1e4,0)
ST2S TAP12 T2C ST2SR 0 SWK
CT2SP TAP12 T2C 15p
RT2SP TAP12 T2C 1G
* ---- L48b (ADR-065, NC-041): C_T 10u fra il trim e il volume, il bilanciamento MN allo
* scatto centrale (la pista da 50k dalla cima a massa, il cursore sulla cima) e il volume:
* KVH e KVL portano il partitore da 0 a -2 dB in cima alla corsa (con att = max: RATTH
* 1m, RATTB 10k; 2,057k in alto, 10k || 38,47k = 7,937k in basso). R_G 1M e' R113 del
* blocco. RBYCT 1m scavalca C_T nel controfattuale (corsa(ct=False)). ----
CT ATOP ATTC 10u
RBYCT ATOP ATTC 1e12
RBAL ATTC 0 50k
CWIRE ATTC 0 100p
RATTH ATTC VH 1m
RVOLH VH W 2.057k
RVOLL W VL 38.47k
VKVHI NKVHI 0 DC 0
VKVHT NKVHT 0 DC 1000
BKVHR SKVHR 0 V = (1 - V(NKVHI)) * pwl(time - V(NKVHT), -1e4,0, 0,0, 1u,1, 150u,1, 151u,0, 300u,0, 301u,1, 450u,1, 451u,0, 520u,0, 521u,1, 1e4,1)
+ + V(NKVHI) * pwl(time - V(NKVHT), -1e4,1, 0,1, 1u,0, 400u,0, 401u,1, 600u,1, 601u,0, 1e4,0)
SKVH VH W SKVHR 0 SWK
VKVLI NKVLI 0 DC 0
VKVLT NKVLT 0 DC 1000
BKVLR SKVLR 0 V = (1 - V(NKVLI)) * pwl(time - V(NKVLT), -1e4,0, 0,0, 1u,1, 150u,1, 151u,0, 300u,0, 301u,1, 450u,1, 451u,0, 520u,0, 521u,1, 1e4,1)
+ + V(NKVLI) * pwl(time - V(NKVLT), -1e4,1, 0,1, 1u,0, 400u,0, 401u,1, 600u,1, 601u,0, 1e4,0)
SKVL VL 0 SKVLR 0 SWK
* ---- L29c: la sonda del gruppo B (limitations #29), su nodi propri (#24) ----
VPRBD PRBD 0 DC 15
VPRBG PRBG 0 DC 0
JPRB PRBD PRBG 0 LSK489A
* ---- L29c: il punto di partenza di Newton per l'op (limitations #33) ----
* Con l'interruttore del trim fra OUTA e W il blocco A ha una seconda soluzione in continua,
* agganciata al rail (+13 V): gmin e source stepping falliscono e il 'transient op' finisce
* li', 'successfully'. Il nodeset e' solo il primo tentativo di Newton: la soluzione resta
* una soluzione del circuito, e ridà quella del deck di main (sonde/op/, controfattuale).
.nodeset V(OUTA)=0 V(W)=0 V(ATOP)=0 V(OUTB)=0 V(MAIN_A)=0 V(OUTF1)=0 V(OUTF2)=0

.control
* limitations #30: il tempo a 16 cifre, prima di ogni wrdata
set numdgt=15
set d = .dat
* L29c: corri.sh rifiuta ogni corsa col 'Transient op' nel log (limitations #33).
save v(mainjack) v(fixjack1) v(fixjack2) v(ina) v(vplus) v(vminus) v(main_a) v(mainc) v(fixc1) v(fixc2)
echo "cella,file,variante,f_hz,amp,gm,rl,t_ins,t_rel,t_fine,tmax,tipo,rif_ins,rif_rel,t_grad,gruppo,conta" > tb_v2_casopeggiore_manifest.csv
* la sorgente arriva dalla RSRC del blocco, col selettore chiuso (L47c2b1: niente LDR)
alter vphs dc = 1.5707963267948966
alter vmhjk dc = 1
* il trim porta OUTA all'attenuatore: RATTT del blocco aperto
alter rattt = 1e12
* ---- L41c: rif_f_u505a_cieco_gu501_l41c (dal ponte: f_u505a_cieco_gu501, giro 1) ----
alter vamp dc = 0
alter vfrq dc = 1000
alter rldm = 100k
alter rld1 = 100k
alter rld2 = 100k
alter vtijk dc = 1000.024000
alter vtrjk dc = 1000.000000
alter vosa dc = 0
alter iosa dc = 0
alter vosb dc = 0
alter vosf1 dc = 0
alter vosf2 dc = 0
alter ratth = 1m
alter rattb = 10k
alter rl1 = 845
alter cwire = 100p
alter rbyct = 1e12
alter rbal = 50k
alter vk1bi dc = 1
alter vk1bt dc = 1000.000000
alter vk5bi dc = 1
alter vk5bt dc = 1000.000000
alter vk1i dc = 0
alter vk1t dc = 1000.000000
alter vk5i dc = 0
alter vk5t dc = 1000.000000
alter vt1ri dc = 1
alter vt1rt dc = 1000.000000
alter vt1si dc = 0
alter vt1st dc = 1000.000000
alter vt2ri dc = 1
alter vt2rt dc = 1000.000000
alter vt2si dc = 0
alter vt2st dc = 1000.000000
alter vkvhi dc = 1
alter vkvht dc = 1000.000000
alter vkvli dc = 0
alter vkvlt dc = 1000.000000
alter vtijk dc = 1000.000000
alter vtrjk dc = 2000.000000
alter vksa dc = -10
alter vksb dc = 1000
alter vkca dc = 1000.025000
alter vkcb dc = 1000.000000
alter vtiser dc = 1000.024000
alter vtrser dc = 1000.001000
alter rbym = 1e12
alter rby1 = 1e12
alter rby2 = 1e12
alter rbcm = 220k
alter rbc1 = 470k
alter rbc2 = 470k
alter cksm = 0.1p
alter cks1 = 0.1p
alter cks2 = 0.1p
alter ccavm = 1e-18
alter ccav1 = 1e-18
alter ccav2 = 1e-18
print @cksm[capacitance] @cks1[capacitance] @cks2[capacitance] @ccavm[capacitance] @ccav1[capacitance] @ccav2[capacitance]
alter @vpp[pwl] = [ 0.000000000 14.979609 0.990000000 14.979608 1.900000000 14.979608 ]
alter @vmm[pwl] = [ 0.000000000 -14.966540 0.990000000 -14.966540 1.900000000 -14.966540 ]
tran 1e-05 1.9000000000039998 0 1e-05
wrdata rif_f_u505a_cieco_gu501_l41c$d v(mainjack) v(fixjack1) v(fixjack2)
wrdata rif_f_u505a_cieco_gu501_l41c_stati$d v(ina) v(vplus) v(vminus) v(main_a) v(mainc) v(fixc1) v(fixc2)
destroy all
echo "rif_f_u505a_cieco_gu501_l41c,rif_f_u505a_cieco_gu501_l41c.dat,rif,1000,0,10,100k,0.990000000,1000,1.9000000000039998,1e-05,rif_mai,-,-,0.0,0," >> tb_v2_casopeggiore_manifest.csv
* ---- L41c: f_u505a_cieco_gu501_l41c (dal ponte: f_u505a_cieco_gu501, giro 1) ----
alter vamp dc = 0
alter vfrq dc = 1000
alter rldm = 100k
alter rld1 = 100k
alter rld2 = 100k
alter vtijk dc = 1.048900
alter vtrjk dc = 1000.000000
alter vosa dc = 0
alter iosa dc = 0
alter vosb dc = 0
alter vosf1 dc = 0
alter vosf2 dc = 0
alter ratth = 1m
alter rattb = 10k
alter rl1 = 845
alter cwire = 100p
alter rbyct = 1e12
alter rbal = 50k
alter vk1bi dc = 1
alter vk1bt dc = 1.085600
alter vk5bi dc = 1
alter vk5bt dc = 1.085900
alter vk1i dc = 0
alter vk1t dc = 1000.000000
alter vk5i dc = 0
alter vk5t dc = 1000.000000
alter vt1ri dc = 1
alter vt1rt dc = 1000.000000
alter vt1si dc = 0
alter vt1st dc = 1000.000000
alter vt2ri dc = 1
alter vt2rt dc = 1000.000000
alter vt2si dc = 0
alter vt2st dc = 1000.000000
alter vkvhi dc = 1
alter vkvht dc = 1000.000000
alter vkvli dc = 0
alter vkvlt dc = 1000.000000
alter vtijk dc = 1000.000000
alter vtrjk dc = 2000.000000
alter vksa dc = -10
alter vksb dc = 1000
alter vkca dc = 1.049900
alter vkcb dc = 1000.000000
alter vtiser dc = 1.048900
alter vtrser dc = 1000.001000
alter rbym = 1e12
alter rby1 = 1e12
alter rby2 = 1e12
alter rbcm = 220k
alter rbc1 = 470k
alter rbc2 = 470k
alter cksm = 0.1p
alter cks1 = 0.1p
alter cks2 = 0.1p
alter ccavm = 1e-18
alter ccav1 = 1e-18
alter ccav2 = 1e-18
print @cksm[capacitance] @cks1[capacitance] @cks2[capacitance] @ccavm[capacitance] @ccav1[capacitance] @ccav2[capacitance]
alter @vpp[pwl] = [ 0.000000000 14.979609 1.000000000 14.979608 1.000100000 14.964769 1.000300000 14.943124 1.000500000 14.922726 1.000700000 14.903491 1.000900000 14.885336 1.001300000 14.851939 1.001700000 14.821936 1.002100000 14.794813 1.002500000 14.770134 1.002900000 14.747529 1.003400000 14.721716 1.003900000 14.698146 1.004400000 14.676403 1.005000000 14.652253 1.005600000 14.629783 1.006300000 14.605212 1.007100000 14.578766 1.007900000 14.553601 1.009000000 14.520465 1.010300000 14.482754 1.013700000 14.387885 1.019000000 14.244093 1.025500000 14.070426 1.031800000 13.904194 1.038100000 13.739932 1.044500000 13.575050 1.050900000 13.412149 1.057700000 13.241208 1.064500000 13.072448 1.071300000 12.905839 1.078200000 12.738952 1.085100000 12.574223 1.092000000 12.411627 1.099000000 12.248823 1.106000000 12.088156 1.113000000 11.929597 1.120000000 11.773120 1.127100000 11.616505 1.134200000 11.461974 1.141300000 11.309501 1.148500000 11.156952 1.155700000 11.006463 1.163000000 10.855956 1.169300000 10.727724 1.175600000 10.601007 1.182000000 10.473813 1.188400000 10.348145 1.194800000 10.223987 1.201200000 10.101319 1.207700000 9.978242 1.214200000 9.856665 1.220700000 9.736571 1.227200000 9.617941 1.233800000 9.498966 1.240400000 9.381463 1.247000000 9.265415 1.253700000 9.149079 1.260400000 9.034204 1.267100000 8.920772 1.273800000 8.808766 1.280600000 8.696527 1.287400000 8.585719 1.294200000 8.476324 1.301000000 8.368325 1.307900000 8.260144 1.314800000 8.153364 1.321800000 8.046447 1.328700000 7.942431 1.335700000 7.838283 1.342700000 7.735502 1.349800000 7.632630 1.356900000 7.531128 1.364000000 7.430976 1.371200000 7.330776 1.378400000 7.231927 1.385300000 7.138450 1.392300000 7.044854 1.399300000 6.952485 1.406400000 6.860036 1.413500000 6.768817 1.420600000 6.678813 1.427800000 6.588764 1.435000000 6.499931 1.442200000 6.412296 1.449500000 6.324652 1.456800000 6.238207 1.464100000 6.152945 1.471400000 6.068850 1.478800000 5.984777 1.486200000 5.901869 1.493700000 5.819015 1.501200000 5.737326 1.508700000 5.656784 1.516300000 5.576323 1.523900000 5.497008 1.531500000 5.418823 1.539200000 5.340745 1.546900000 5.263792 1.554600000 5.187950 1.562400000 5.112239 1.570200000 5.037634 1.578100000 4.963184 1.586000000 4.889836 1.593900000 4.817573 1.601900000 4.745485 1.609900000 4.674477 1.618000000 4.603666 1.626100000 4.533929 1.634300000 4.464409 1.642500000 4.395956 1.650700000 4.328555 1.659000000 4.261386 1.667300000 4.195260 1.675600000 4.130163 1.684000000 4.065311 1.692400000 4.001479 1.700900000 3.937909 1.709400000 3.875351 1.718000000 3.813070 1.735300000 3.690805 1.752800000 3.571122 1.770500000 3.454026 1.788300000 3.340148 1.806400000 3.228207 1.824700000 3.118851 1.843200000 3.012073 1.861900000 2.907864 1.880800000 2.806211 1.900000000 2.706592 ]
alter @vmm[pwl] = [ 0.000000000 -14.966540 1.200200000 -14.966540 1.200700000 -14.965733 1.201300000 -14.962732 1.201900000 -14.957705 1.202500000 -14.950819 1.203100000 -14.942228 1.203700000 -14.932074 1.204400000 -14.918424 1.205100000 -14.903009 1.205800000 -14.886001 1.206500000 -14.867555 1.207200000 -14.847808 1.208000000 -14.823813 1.208800000 -14.798457 1.209700000 -14.768493 1.210600000 -14.737193 1.211500000 -14.704727 1.212500000 -14.667466 1.213500000 -14.629130 1.215000000 -14.569948 1.216600000 -14.505040 1.218400000 -14.430350 1.220500000 -14.341601 1.224100000 -14.186992 1.235700000 -13.684618 1.239600000 -13.517478 1.243300000 -13.360384 1.246500000 -13.225794 1.249700000 -13.092443 1.252900000 -12.960359 1.256100000 -12.829558 1.260100000 -12.667865 1.264200000 -12.504211 1.268300000 -12.342649 1.272400000 -12.183161 1.276500000 -12.025723 1.280700000 -11.866547 1.284800000 -11.713186 1.289000000 -11.558135 1.292500000 -11.430490 1.296100000 -11.300665 1.299700000 -11.172310 1.303300000 -11.045410 1.306900000 -10.919948 1.310600000 -10.792482 1.314200000 -10.669886 1.317900000 -10.545331 1.321600000 -10.422227 1.325300000 -10.300556 1.329000000 -10.180302 1.332700000 -10.061448 1.336400000 -9.943978 1.340200000 -9.824757 1.343900000 -9.710043 1.347700000 -9.593619 1.352000000 -9.463553 1.356300000 -9.335246 1.360600000 -9.208674 1.365000000 -9.080929 1.369400000 -8.954951 1.373800000 -8.830716 1.378200000 -8.708199 1.382600000 -8.587376 1.387100000 -8.465536 1.391600000 -8.345419 1.396100000 -8.227001 1.400600000 -8.110258 1.405100000 -7.995166 1.409700000 -7.879199 1.414300000 -7.764908 1.418900000 -7.652269 1.423500000 -7.541258 1.428200000 -7.429492 1.432900000 -7.319375 1.437600000 -7.210885 1.442300000 -7.103998 1.447100000 -6.996465 1.451800000 -6.892743 1.456600000 -6.788396 1.461400000 -6.685622 1.466300000 -6.582305 1.471100000 -6.482639 1.476000000 -6.382446 1.480900000 -6.283795 1.485800000 -6.186663 1.490800000 -6.089090 1.495800000 -5.993048 1.500900000 -5.896639 1.506100000 -5.799930 1.511300000 -5.704799 1.516600000 -5.609436 1.521900000 -5.515661 1.527200000 -5.423445 1.532500000 -5.332764 1.537900000 -5.241923 1.543300000 -5.152622 1.548700000 -5.064834 1.554100000 -4.978534 1.559600000 -4.892139 1.565100000 -4.807236 1.570700000 -4.722294 1.576300000 -4.638845 1.581900000 -4.556861 1.587500000 -4.476319 1.593200000 -4.395791 1.598900000 -4.316704 1.604700000 -4.237680 1.610500000 -4.160094 1.616300000 -4.083919 1.622200000 -4.007853 1.628100000 -3.933195 1.634000000 -3.859917 1.640000000 -3.786788 1.646000000 -3.715036 1.652000000 -3.644633 1.658100000 -3.574414 1.664200000 -3.505538 1.670400000 -3.436883 1.676600000 -3.369562 1.682800000 -3.303550 1.689100000 -3.237787 1.695400000 -3.173322 1.701800000 -3.109138 1.708200000 -3.046241 1.714700000 -2.983652 1.721200000 -2.922338 1.727700000 -2.862272 1.734300000 -2.802534 1.740900000 -2.744032 1.747600000 -2.685880 1.754300000 -2.628948 1.761100000 -2.572389 1.767900000 -2.517034 1.774800000 -2.462070 1.781700000 -2.408293 1.788700000 -2.354924 1.795700000 -2.302725 1.802800000 -2.250949 1.809900000 -2.200324 1.817100000 -2.150135 1.824300000 -2.101077 1.831600000 -2.052466 1.839000000 -2.004322 1.846400000 -1.957294 1.853900000 -1.910741 1.861400000 -1.865280 1.869000000 -1.820302 1.876700000 -1.775822 1.884400000 -1.732413 1.892200000 -1.689506 1.900000000 -1.647646 ]
tran 1e-05 1.9000000000039998 0 1e-05
wrdata f_u505a_cieco_gu501_l41c$d v(mainjack) v(fixjack1) v(fixjack2)
wrdata f_u505a_cieco_gu501_l41c_stati$d v(ina) v(vplus) v(vminus) v(main_a) v(mainc) v(fixc1) v(fixc2)
destroy all
echo "f_u505a_cieco_gu501_l41c,f_u505a_cieco_gu501_l41c.dat,l41c_f_u505a_cieco_gu501,1000,0,10a0,100k,0.990000000,1000,1.9000000000039998,1e-05,evento,rif_f_u505a_cieco_gu501_l41c,-,0.0,6,A_ins" >> tb_v2_casopeggiore_manifest.csv
* ---- L41c: rif_f_u505b_cieco_gu502_l41c (dal ponte: f_u505b_cieco_gu502, giro 1) ----
alter vamp dc = 0
alter vfrq dc = 1000
alter rldm = 100k
alter rld1 = 100k
alter rld2 = 100k
alter vtijk dc = 1000.024000
alter vtrjk dc = 1000.000000
alter vosa dc = 0
alter iosa dc = 0
alter vosb dc = 0
alter vosf1 dc = 0
alter vosf2 dc = 0
alter ratth = 1m
alter rattb = 10k
alter rl1 = 845
alter cwire = 100p
alter rbyct = 1e12
alter rbal = 50k
alter vk1bi dc = 1
alter vk1bt dc = 1000.000000
alter vk5bi dc = 1
alter vk5bt dc = 1000.000000
alter vk1i dc = 0
alter vk1t dc = 1000.000000
alter vk5i dc = 0
alter vk5t dc = 1000.000000
alter vt1ri dc = 1
alter vt1rt dc = 1000.000000
alter vt1si dc = 0
alter vt1st dc = 1000.000000
alter vt2ri dc = 1
alter vt2rt dc = 1000.000000
alter vt2si dc = 0
alter vt2st dc = 1000.000000
alter vkvhi dc = 1
alter vkvht dc = 1000.000000
alter vkvli dc = 0
alter vkvlt dc = 1000.000000
alter vtijk dc = 1000.000000
alter vtrjk dc = 2000.000000
alter vksa dc = -10
alter vksb dc = 1000
alter vkca dc = 1000.025000
alter vkcb dc = 1000.000000
alter vtiser dc = 1000.024000
alter vtrser dc = 1000.001000
alter rbym = 1e12
alter rby1 = 1e12
alter rby2 = 1e12
alter rbcm = 220k
alter rbc1 = 470k
alter rbc2 = 470k
alter cksm = 0.1p
alter cks1 = 0.1p
alter cks2 = 0.1p
alter ccavm = 1e-18
alter ccav1 = 1e-18
alter ccav2 = 1e-18
print @cksm[capacitance] @cks1[capacitance] @cks2[capacitance] @ccavm[capacitance] @ccav1[capacitance] @ccav2[capacitance]
alter @vpp[pwl] = [ 0.000000000 14.979609 0.990000000 14.979609 2.000000000 14.979609 ]
alter @vmm[pwl] = [ 0.000000000 -14.966540 0.990000000 -14.966540 2.000000000 -14.966540 ]
tran 1e-05 2.0000000000040004 0 1e-05
wrdata rif_f_u505b_cieco_gu502_l41c$d v(mainjack) v(fixjack1) v(fixjack2)
wrdata rif_f_u505b_cieco_gu502_l41c_stati$d v(ina) v(vplus) v(vminus) v(main_a) v(mainc) v(fixc1) v(fixc2)
destroy all
echo "rif_f_u505b_cieco_gu502_l41c,rif_f_u505b_cieco_gu502_l41c.dat,rif,1000,0,10,100k,0.990000000,1000,2.0000000000040004,1e-05,rif_mai,-,-,0.0,0," >> tb_v2_casopeggiore_manifest.csv
* ---- L41c: f_u505b_cieco_gu502_l41c (dal ponte: f_u505b_cieco_gu502, giro 1) ----
alter vamp dc = 0
alter vfrq dc = 1000
alter rldm = 100k
alter rld1 = 100k
alter rld2 = 100k
alter vtijk dc = 1.016200
alter vtrjk dc = 1000.000000
alter vosa dc = 0
alter iosa dc = 0
alter vosb dc = 0
alter vosf1 dc = 0
alter vosf2 dc = 0
alter ratth = 1m
alter rattb = 10k
alter rl1 = 845
alter cwire = 100p
alter rbyct = 1e12
alter rbal = 50k
alter vk1bi dc = 1
alter vk1bt dc = 1.052900
alter vk5bi dc = 1
alter vk5bt dc = 1.053200
alter vk1i dc = 0
alter vk1t dc = 1000.000000
alter vk5i dc = 0
alter vk5t dc = 1000.000000
alter vt1ri dc = 1
alter vt1rt dc = 1000.000000
alter vt1si dc = 0
alter vt1st dc = 1000.000000
alter vt2ri dc = 1
alter vt2rt dc = 1000.000000
alter vt2si dc = 0
alter vt2st dc = 1000.000000
alter vkvhi dc = 1
alter vkvht dc = 1000.000000
alter vkvli dc = 0
alter vkvlt dc = 1000.000000
alter vtijk dc = 1000.000000
alter vtrjk dc = 2000.000000
alter vksa dc = -10
alter vksb dc = 1000
alter vkca dc = 1.017200
alter vkcb dc = 1000.000000
alter vtiser dc = 1.016200
alter vtrser dc = 1000.001000
alter rbym = 1e12
alter rby1 = 1e12
alter rby2 = 1e12
alter rbcm = 220k
alter rbc1 = 470k
alter rbc2 = 470k
alter cksm = 0.1p
alter cks1 = 0.1p
alter cks2 = 0.1p
alter ccavm = 1e-18
alter ccav1 = 1e-18
alter ccav2 = 1e-18
print @cksm[capacitance] @cks1[capacitance] @cks2[capacitance] @ccavm[capacitance] @ccav1[capacitance] @ccav2[capacitance]
alter @vpp[pwl] = [ 0.000000000 14.979609 1.172000000 14.979609 1.172500000 14.978852 1.173000000 14.976812 1.173700000 14.972287 1.174400000 14.966269 1.175200000 14.958036 1.176000000 14.948728 1.178000000 14.922330 1.180400000 14.887057 1.183300000 14.841333 1.186500000 14.788216 1.190000000 14.727755 1.193900000 14.658176 1.199400000 14.557184 1.205900000 14.434973 1.212600000 14.307146 1.230600000 13.961210 1.239900000 13.783371 1.250000000 13.591938 1.259700000 13.410111 1.270400000 13.212061 1.281100000 13.016763 1.291700000 12.826044 1.302300000 12.638069 1.311300000 12.480609 1.320300000 12.325096 1.329300000 12.171513 1.338400000 12.018162 1.347500000 11.866738 1.356600000 11.717217 1.365800000 11.567965 1.375000000 11.420610 1.386000000 11.246882 1.397100000 11.074250 1.408200000 10.904262 1.419400000 10.735383 1.430600000 10.569116 1.441900000 10.403968 1.453300000 10.239969 1.464700000 10.078551 1.476200000 9.918290 1.487700000 9.760573 1.499300000 9.604020 1.510900000 9.449973 1.522600000 9.297096 1.534400000 9.145413 1.546300000 8.994945 1.558200000 8.846948 1.570700000 8.694105 1.583300000 8.542705 1.596000000 8.392766 1.608700000 8.245453 1.621500000 8.099591 1.634400000 7.955193 1.647400000 7.812275 1.660500000 7.670848 1.673600000 7.531975 1.686800000 7.394579 1.700100000 7.258670 1.713500000 7.124260 1.727000000 6.991356 1.740500000 6.860925 1.754100000 6.731982 1.767800000 6.604534 1.781600000 6.478589 1.795500000 6.354151 1.809500000 6.231227 1.823600000 6.109822 1.837800000 5.989939 1.852000000 5.872401 1.866400000 5.755556 1.880800000 5.641028 1.895400000 5.527228 1.910000000 5.415716 1.924700000 5.305706 1.939600000 5.196472 1.954500000 5.089478 1.969600000 4.983288 1.984700000 4.879305 2.000000000 4.776150 ]
alter @vmm[pwl] = [ 0.000000000 -14.966540 1.000000000 -14.966540 1.000100000 -14.950886 1.002000000 -14.723244 1.003700000 -14.522410 1.005400000 -14.324316 1.006900000 -14.151774 1.008500000 -13.970020 1.010000000 -13.801747 1.011600000 -13.624490 1.013100000 -13.460381 1.014600000 -13.298249 1.016100000 -13.138071 1.017700000 -12.969342 1.019200000 -12.813128 1.020800000 -12.648573 1.022400000 -12.486133 1.024000000 -12.325780 1.025500000 -12.177321 1.027100000 -12.020936 1.028700000 -11.866560 1.030300000 -11.714167 1.031900000 -11.563733 1.033500000 -11.415232 1.035100000 -11.268638 1.036700000 -11.123928 1.038300000 -10.981078 1.039900000 -10.840062 1.041500000 -10.700859 1.043200000 -10.554915 1.044800000 -10.419375 1.046500000 -10.277272 1.048100000 -10.145300 1.049800000 -10.006937 1.051400000 -9.878438 1.053100000 -9.743716 1.054800000 -9.610833 1.056500000 -9.479763 1.058200000 -9.350482 1.059900000 -9.222965 1.061600000 -9.097189 1.063400000 -8.965883 1.065100000 -8.843615 1.066900000 -8.715972 1.068600000 -8.597113 1.070400000 -8.473031 1.072100000 -8.357488 1.073900000 -8.236866 1.075700000 -8.117986 1.077500000 -8.000824 1.079300000 -7.885353 1.081100000 -7.771550 1.082900000 -7.659391 1.084800000 -7.542758 1.086600000 -7.433904 1.088500000 -7.320707 1.090300000 -7.215059 1.092200000 -7.105197 1.094100000 -6.997010 1.096000000 -6.890471 1.097900000 -6.785555 1.099800000 -6.682238 1.101700000 -6.580496 1.103600000 -6.480305 1.105500000 -6.381640 1.107500000 -6.279406 1.109400000 -6.183803 1.111400000 -6.084741 1.113300000 -5.992104 1.115300000 -5.896117 1.117300000 -5.801668 1.119300000 -5.708734 1.121300000 -5.617290 1.123300000 -5.527313 1.125300000 -5.438778 1.127400000 -5.347344 1.129400000 -5.261695 1.131500000 -5.173241 1.133600000 -5.086276 1.135700000 -5.000774 1.137800000 -4.916711 1.139900000 -4.834063 1.142000000 -4.752806 1.144200000 -4.669147 1.146300000 -4.590665 1.148500000 -4.509863 1.150700000 -4.430484 1.152900000 -4.352505 1.155100000 -4.275900 1.157300000 -4.200645 1.159500000 -4.126717 1.161800000 -4.050820 1.164000000 -3.979532 1.166300000 -3.906347 1.168600000 -3.834509 1.170900000 -3.763995 1.173200000 -3.694779 1.175500000 -3.626838 1.177800000 -3.560148 1.180200000 -3.491868 1.182500000 -3.427664 1.184900000 -3.361929 1.187300000 -3.297457 1.189700000 -3.234223 1.192100000 -3.172205 1.194600000 -3.108868 1.197000000 -3.049258 1.199500000 -2.988380 1.202000000 -2.928721 1.204500000 -2.870255 1.207000000 -2.812959 1.209600000 -2.754586 1.212100000 -2.699603 1.214700000 -2.643587 1.217300000 -2.588737 1.219900000 -2.535026 1.222500000 -2.482433 1.225200000 -2.428974 1.227900000 -2.376669 1.230600000 -2.325493 1.233300000 -2.275422 1.236000000 -2.226432 1.238700000 -2.178499 1.241500000 -2.129883 1.244300000 -2.082356 1.247100000 -2.035891 1.249900000 -1.990467 1.252800000 -1.944491 1.255700000 -1.899580 1.258600000 -1.855710 1.263900000 -1.778143 1.269200000 -1.703828 1.274600000 -1.631315 1.280100000 -1.560642 1.285700000 -1.491839 1.291400000 -1.424935 1.297200000 -1.359947 1.303000000 -1.297936 1.309000000 -1.236773 1.315000000 -1.178505 1.321100000 -1.122093 1.327300000 -1.067536 1.333600000 -1.014830 1.340100000 -0.963192 1.346700000 -0.913463 1.353400000 -0.865621 1.360200000 -0.819644 1.367100000 -0.775502 1.374100000 -0.733167 1.381300000 -0.692051 1.388600000 -0.652736 1.396100000 -0.614688 1.403700000 -0.578415 1.411500000 -0.543433 1.419500000 -0.509774 1.427600000 -0.477840 1.435900000 -0.447216 1.444400000 -0.417912 1.453100000 -0.389932 1.462000000 -0.363274 1.471100000 -0.337929 1.480400000 -0.313882 1.489400000 -0.292271 1.498600000 -0.271745 1.508100000 -0.252093 1.517800000 -0.233524 1.527800000 -0.215846 1.538000000 -0.199227 1.548500000 -0.183493 1.559400000 -0.168511 1.570600000 -0.154433 1.582100000 -0.141244 1.594000000 -0.128827 1.606200000 -0.117278 1.618900000 -0.106407 1.632000000 -0.096303 1.645600000 -0.086886 1.659800000 -0.078098 1.688900000 -0.062953 1.720500000 -0.050078 1.755000000 -0.039312 1.793100000 -0.030439 1.835100000 -0.023356 1.882500000 -0.017780 1.936600000 -0.013548 2.000000000 -0.010455 ]
tran 1e-05 2.0000000000040004 0 1e-05
wrdata f_u505b_cieco_gu502_l41c$d v(mainjack) v(fixjack1) v(fixjack2)
wrdata f_u505b_cieco_gu502_l41c_stati$d v(ina) v(vplus) v(vminus) v(main_a) v(mainc) v(fixc1) v(fixc2)
destroy all
echo "f_u505b_cieco_gu502_l41c,f_u505b_cieco_gu502_l41c.dat,l41c_f_u505b_cieco_gu502,1000,0,10a0,100k,0.990000000,1000,2.0000000000040004,1e-05,evento,rif_f_u505b_cieco_gu502_l41c,-,0.0,6,A_ins" >> tb_v2_casopeggiore_manifest.csv
* ---- L41c: rif_corto_u503_l41c (dal ponte: corto_u503, giro 1) ----
alter vamp dc = 0
alter vfrq dc = 1000
alter rldm = 100k
alter rld1 = 100k
alter rld2 = 100k
alter vtijk dc = 1000.024000
alter vtrjk dc = 1000.000000
alter vosa dc = 0
alter iosa dc = 0
alter vosb dc = 0
alter vosf1 dc = 0
alter vosf2 dc = 0
alter ratth = 1m
alter rattb = 10k
alter rl1 = 845
alter cwire = 100p
alter rbyct = 1e12
alter rbal = 50k
alter vk1bi dc = 1
alter vk1bt dc = 1000.000000
alter vk5bi dc = 1
alter vk5bt dc = 1000.000000
alter vk1i dc = 0
alter vk1t dc = 1000.000000
alter vk5i dc = 0
alter vk5t dc = 1000.000000
alter vt1ri dc = 1
alter vt1rt dc = 1000.000000
alter vt1si dc = 0
alter vt1st dc = 1000.000000
alter vt2ri dc = 1
alter vt2rt dc = 1000.000000
alter vt2si dc = 0
alter vt2st dc = 1000.000000
alter vkvhi dc = 1
alter vkvht dc = 1000.000000
alter vkvli dc = 0
alter vkvlt dc = 1000.000000
alter vtijk dc = 1000.000000
alter vtrjk dc = 2000.000000
alter vksa dc = -10
alter vksb dc = 1000
alter vkca dc = 1000.025000
alter vkcb dc = 1000.000000
alter vtiser dc = 1000.024000
alter vtrser dc = 1000.001000
alter rbym = 1e12
alter rby1 = 1e12
alter rby2 = 1e12
alter rbcm = 220k
alter rbc1 = 470k
alter rbc2 = 470k
alter cksm = 0.1p
alter cks1 = 0.1p
alter cks2 = 0.1p
alter ccavm = 1e-18
alter ccav1 = 1e-18
alter ccav2 = 1e-18
print @cksm[capacitance] @cks1[capacitance] @cks2[capacitance] @ccavm[capacitance] @ccav1[capacitance] @ccav2[capacitance]
alter @vpp[pwl] = [ 0.000000000 14.979609 0.990000000 14.979609 2.000000000 14.979609 ]
alter @vmm[pwl] = [ 0.000000000 -14.966540 0.990000000 -14.966543 2.000000000 -14.966543 ]
tran 1e-05 2.0000000000040004 0 1e-05
wrdata rif_corto_u503_l41c$d v(mainjack) v(fixjack1) v(fixjack2)
wrdata rif_corto_u503_l41c_stati$d v(ina) v(vplus) v(vminus) v(main_a) v(mainc) v(fixc1) v(fixc2)
destroy all
echo "rif_corto_u503_l41c,rif_corto_u503_l41c.dat,rif,1000,0,10,100k,0.990000000,1000,2.0000000000040004,1e-05,rif_mai,-,-,0.0,0," >> tb_v2_casopeggiore_manifest.csv
* ---- L41c: corto_u503_l41c (dal ponte: corto_u503, giro 1) ----
alter vamp dc = 0
alter vfrq dc = 1000
alter rldm = 100k
alter rld1 = 100k
alter rld2 = 100k
alter vtijk dc = 1.003100
alter vtrjk dc = 1000.000000
alter vosa dc = 0
alter iosa dc = 0
alter vosb dc = 0
alter vosf1 dc = 0
alter vosf2 dc = 0
alter ratth = 1m
alter rattb = 10k
alter rl1 = 845
alter cwire = 100p
alter rbyct = 1e12
alter rbal = 50k
alter vk1bi dc = 1
alter vk1bt dc = 1.000100
alter vk5bi dc = 1
alter vk5bt dc = 1.000400
alter vk1i dc = 0
alter vk1t dc = 1000.000000
alter vk5i dc = 0
alter vk5t dc = 1000.000000
alter vt1ri dc = 1
alter vt1rt dc = 1000.000000
alter vt1si dc = 0
alter vt1st dc = 1000.000000
alter vt2ri dc = 1
alter vt2rt dc = 1000.000000
alter vt2si dc = 0
alter vt2st dc = 1000.000000
alter vkvhi dc = 1
alter vkvht dc = 1000.000000
alter vkvli dc = 0
alter vkvlt dc = 1000.000000
alter vtijk dc = 1000.000000
alter vtrjk dc = 2000.000000
alter vksa dc = -10
alter vksb dc = 1000
alter vkca dc = 1.004100
alter vkcb dc = 1000.000000
alter vtiser dc = 1.003100
alter vtrser dc = 1000.001000
alter rbym = 1e12
alter rby1 = 1e12
alter rby2 = 1e12
alter rbcm = 220k
alter rbc1 = 470k
alter rbc2 = 470k
alter cksm = 0.1p
alter cks1 = 0.1p
alter cks2 = 0.1p
alter ccavm = 1e-18
alter ccav1 = 1e-18
alter ccav2 = 1e-18
print @cksm[capacitance] @cks1[capacitance] @cks2[capacitance] @ccavm[capacitance] @ccav1[capacitance] @ccav2[capacitance]
alter @vpp[pwl] = [ 0.000000000 14.979609 1.042000000 14.979609 1.042500000 14.978849 1.043100000 14.976269 1.043700000 14.972280 1.044400000 14.966261 1.045200000 14.958026 1.046000000 14.948717 1.048000000 14.922318 1.050400000 14.887043 1.053200000 14.842938 1.056400000 14.789895 1.059900000 14.729495 1.063700000 14.661775 1.069100000 14.562744 1.075400000 14.444435 1.082200000 14.314793 1.101200000 13.949684 1.111300000 13.756702 1.122300000 13.548619 1.132800000 13.352437 1.144600000 13.135053 1.156300000 12.922843 1.168000000 12.713977 1.179700000 12.508443 1.190400000 12.323364 1.201100000 12.141010 1.211800000 11.961346 1.222600000 11.782692 1.233500000 11.605084 1.244400000 11.430148 1.255400000 11.256276 1.266400000 11.085044 1.279100000 10.890581 1.291900000 10.698032 1.304800000 10.507417 1.317700000 10.320192 1.330700000 10.134885 1.343800000 9.951512 1.357000000 9.770089 1.370200000 9.591967 1.383500000 9.415773 1.396900000 9.241522 1.410400000 9.069224 1.424000000 8.898891 1.437700000 8.730534 1.451400000 8.565355 1.465300000 8.400951 1.479200000 8.239696 1.493700000 8.074771 1.508300000 7.912036 1.523000000 7.751492 1.537800000 7.593139 1.552700000 7.436976 1.567700000 7.283000 1.582800000 7.131210 1.598100000 6.980628 1.613400000 6.833216 1.628900000 6.687044 1.644400000 6.543989 1.660100000 6.402200 1.675900000 6.262600 1.691800000 6.125181 1.707800000 5.989932 1.723900000 5.856842 1.740100000 5.725902 1.756500000 5.596317 1.773000000 5.468891 1.789700000 5.342866 1.806400000 5.219734 1.823300000 5.098007 1.840300000 4.978413 1.857500000 4.860256 1.874800000 4.744231 1.892300000 4.629672 1.909900000 4.517236 1.927600000 4.406905 1.945500000 4.298056 1.963500000 4.191299 1.981700000 4.086040 2.000000000 3.982855 ]
alter @vmm[pwl] = [ 0.000000000 -14.966540 1.040200000 -14.966543 1.040800000 -14.965393 1.041400000 -14.962051 1.042000000 -14.956711 1.042600000 -14.949538 1.043200000 -14.940685 1.043800000 -14.930290 1.044400000 -14.918481 1.045100000 -14.903074 1.045800000 -14.886072 1.046500000 -14.867631 1.047200000 -14.847891 1.048000000 -14.823902 1.048800000 -14.798552 1.049600000 -14.771993 1.050400000 -14.744361 1.051300000 -14.712146 1.052200000 -14.678881 1.053200000 -14.640856 1.054700000 -14.582057 1.056400000 -14.513377 1.058200000 -14.438867 1.060300000 -14.350267 1.064000000 -14.191483 1.072300000 -13.831604 1.076500000 -13.650427 1.080800000 -13.466588 1.085000000 -13.288970 1.088900000 -13.125913 1.092700000 -12.968839 1.096600000 -12.809509 1.100400000 -12.656103 1.105100000 -12.468864 1.109900000 -12.280474 1.114700000 -12.094914 1.119500000 -11.912146 1.124300000 -11.732131 1.129200000 -11.551164 1.134100000 -11.372981 1.139000000 -11.197540 1.143600000 -11.035298 1.148200000 -10.875401 1.152800000 -10.717815 1.157400000 -10.562508 1.162000000 -10.409445 1.166700000 -10.255340 1.171400000 -10.103510 1.176100000 -9.953923 1.180800000 -9.806544 1.185600000 -9.658276 1.190400000 -9.512243 1.195200000 -9.368413 1.200000000 -9.226751 1.204900000 -9.084342 1.209800000 -8.944124 1.214700000 -8.806063 1.220100000 -8.656376 1.225500000 -8.509224 1.230900000 -8.364567 1.236400000 -8.219751 1.241900000 -8.077434 1.247400000 -7.937574 1.253000000 -7.797650 1.258600000 -7.660185 1.264200000 -7.525135 1.269900000 -7.390109 1.275600000 -7.257499 1.281300000 -7.127259 1.287100000 -6.997125 1.292900000 -6.869358 1.298700000 -6.743915 1.304600000 -6.618651 1.310500000 -6.495704 1.316500000 -6.373007 1.322500000 -6.252617 1.328500000 -6.134493 1.334600000 -6.016677 1.340700000 -5.901115 1.346800000 -5.787763 1.353000000 -5.674774 1.359200000 -5.563980 1.365500000 -5.453605 1.371800000 -5.345409 1.378100000 -5.239349 1.384500000 -5.133750 1.390900000 -5.030269 1.397400000 -4.927295 1.403900000 -4.826417 1.410000000 -4.733618 1.416200000 -4.641115 1.422400000 -4.550410 1.428600000 -4.461467 1.434900000 -4.372861 1.441200000 -4.286004 1.447600000 -4.199524 1.454000000 -4.114779 1.460400000 -4.031733 1.466900000 -3.949094 1.473400000 -3.868139 1.480000000 -3.787624 1.486600000 -3.708774 1.493300000 -3.630397 1.500000000 -3.553665 1.506800000 -3.477433 1.513600000 -3.402825 1.520500000 -3.328744 1.527400000 -3.256264 1.534400000 -3.184332 1.541400000 -3.113978 1.548500000 -3.044193 1.555600000 -2.975959 1.562800000 -2.908313 1.570000000 -2.842191 1.577300000 -2.776671 1.584700000 -2.711782 1.592100000 -2.648395 1.599600000 -2.585649 1.607100000 -2.524375 1.614700000 -2.463751 1.622300000 -2.404568 1.630800000 -2.340041 1.639400000 -2.276499 1.648100000 -2.213954 1.656900000 -2.152418 1.665800000 -2.091903 1.674700000 -2.033069 1.683700000 -1.975237 1.692800000 -1.918413 1.702000000 -1.862605 1.711300000 -1.807818 1.720700000 -1.754058 1.730100000 -1.701874 1.739700000 -1.650159 1.749300000 -1.599992 1.759100000 -1.550329 1.769000000 -1.501698 1.770400000 -1.487209 1.777700000 -1.406288 1.782800000 -1.351067 1.787900000 -1.297526 1.792900000 -1.246767 1.798200000 -1.194876 1.803400000 -1.145982 1.808700000 -1.098215 1.814100000 -1.051606 1.819800000 -1.004566 1.825500000 -0.959643 1.831400000 -0.915273 1.837300000 -0.872969 1.843300000 -0.831968 1.849400000 -0.792272 1.855600000 -0.753882 1.862000000 -0.716221 1.869300000 -0.675576 1.876700000 -0.636750 1.884300000 -0.599219 1.892000000 -0.563474 1.899900000 -0.529042 1.908000000 -0.495947 1.916300000 -0.464210 1.924700000 -0.434186 1.933300000 -0.405488 1.942100000 -0.378116 1.951100000 -0.352064 1.960400000 -0.327063 1.969900000 -0.303392 1.979700000 -0.280805 1.989700000 -0.259529 2.000000000 -0.239341 ]
tran 1e-05 2.0000000000040004 0 1e-05
wrdata corto_u503_l41c$d v(mainjack) v(fixjack1) v(fixjack2)
wrdata corto_u503_l41c_stati$d v(ina) v(vplus) v(vminus) v(main_a) v(mainc) v(fixc1) v(fixc2)
destroy all
echo "corto_u503_l41c,corto_u503_l41c.dat,l41c_corto_u503,1000,0,10a0,100k,0.990000000,1000,2.0000000000040004,1e-05,evento,rif_corto_u503_l41c,-,0.0,6,A_ins" >> tb_v2_casopeggiore_manifest.csv
.endc

.end
