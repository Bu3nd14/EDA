tb_v2_casopeggiore.cir - V2 al jack, il caso peggiore col mute reale: LDR VTL5C4 v4 a monte e rele' al jack, guadagno, trim, dispersione, accensione (L29c, NC-028)
* Prima riga = titolo (docs/limitations.md #10).
* GENERATO da docs/preamp/data/2026-09-23/L29c/deck/genera_tb_v2_casopeggiore.py: non si
* edita a mano. L'intestazione del generatore dice cosa c'e' dentro, le ipotesi di
* accensione e spegnimento, e come si corre. Matrice: l41c. Curve: serie B, derivazione B.
* MATRICE sorgente (L29e, ADR-044): il mute al jack e' la geometria iii com'e' in
* circuits/preamp/preamp_audio.net - un deviatore per uscita, COM al lato del condensatore,
* NC a massa, NO al jack. Il generatore la LEGGE dalla netlist col controllo del 2e e rifiuta
* se non c'e'; i bleed lato condensatore (rbcm/rbc1/rbc2) sono i valori della netlist, il
* bleed del jack deve coincidere con RBLx del blocco. Dal banco restano: il contatto aperto
* 0,1 pF (datasheet, L29d2), il trasferimento 1 ms (ipotesi) e 0 pF di cavo (caso peggiore).
* Nomi e righe sono quelli di L29d2 (suffisso _iii), variante di progetto.
*
* IL MODELLO DELLE CELLE e' comportamentale dal datasheet, con estrapolazione dichiarata
* (models/optocoupler/vtl5c4_comportamentale.lib). Ogni dispositivo attivo e' il modello del
* costruttore in models/ (L39); nessuno porta la dispersione, che qui si inietta: VOS* e
* `altermod lsk489a vto` (gruppo B, ADR-031). UN MODELLO ALTERATO PORTA ANCORA IL NOME
* LSK489A (limitations #29): le corse alterate lo dicono nel nome (_gb*) e stampano showmod
* e la corrente della sonda JPRB.
*
* IL PROFILO v4, Td 6 s (ADR-039, ADR-040). Rele' al jack chiuso 0,5 s dopo d = 1.
* ANALISI: scripts/v2_metodo.py analizza sul manifesto; le colonne gruppo e conta dicono
* quali grandezze di ogni riga sono verdetto. Si corre DIVISO (dividi.py): le corse di
* accensione alterano le sorgenti dei rail, e in sequenza l'alterazione resterebbe.
* CONVENZIONE DI PERCORSO: `.include @REPO@/...` (tb_op.cir, L2-L3).

.include @REPO@/models/jfet/lsk489.lib
.include @REPO@/models/bjt_npn/mmbt5551.lib
.include @REPO@/models/bjt_pnp/mmbt5401.lib
.include @REPO@/models/bjt_npn/mje15032.lib
.include @REPO@/models/bjt_pnp/mje15033.lib
.include @REPO@/models/diodes/1n4148.lib
.include @REPO@/models/bjt_pnp/ls350.lib
.include @REPO@/spice/preamp/gain_block.subckt
.include @REPO@/models/optocoupler/vtl5c4_comportamentale.lib

* >>> CANALE - identico nei tre deck tb_v2_mute_*.cir (v2_metodo.py canale)
* TOLLERANZE (L29a, ripresa 2026-09-16): vedi il blocco esteso in
* tb_v2_mute_varianti.cir. vntol=1e-9 rendeva il deck non eseguibile (41 ore
* per una cella senza segnale); vntol=1e-6 la fa in 5,5 s e le cifre non
* cambiano - verificato, data/2026-09-16/L29a/tolleranze/.
.options reltol=1e-6 vntol=1e-6 abstol=1e-12
VPP VPLUS 0 DC 15
VMM VMINUS 0 DC -15

* ---- sorgente con inviluppo d'entrata ----
VAMP NAMP 0 DC 3.818
VFRQ NFRQ 0 DC 1000
VPHS NPHS 0 DC 0
VTEN NTEN 0 DC 0.3
BSRC SRC 0 V = V(NAMP) * sin(6.283185307179586*V(NFRQ)*time + V(NPHS))
+ * (0.5 - 0.5*cos(3.141592653589793*min(time/V(NTEN), 1)))
RSRC SRC SELA 1.5

* ---- stati dei contatti: t_ins, t_rel, durata graduale, netto(1)/graduale(0) ----
VTIJK NTIJK 0 DC 1000
VTRJK NTRJK 0 DC 2000
VTGJK NTGJK 0 DC 1
VMHJK NMHJK 0 DC 1
BSJKR SJKR 0 V = V(NMHJK)
+ * pwl(time - V(NTIJK), -1e4,0, 0,0, 1u,1, 150u,1, 151u,0, 300u,0, 301u,1, 450u,1, 451u,0, 520u,0, 521u,1, 1e4,1)
+ * pwl(time - V(NTRJK), -1e4,1, 0,1, 1u,0, 400u,0, 401u,1, 600u,1, 601u,0, 1e4,0)
+ + (1 - V(NMHJK)) * min(max((time - V(NTIJK))/V(NTGJK), 0), 1)
+ * (1 - min(max((time - V(NTRJK))/V(NTGJK), 0), 1))
RSJK SJKR SJK 1k
CSJK SJK 0 4.55n
VTIPRE NTIPRE 0 DC 1000
VTRPRE NTRPRE 0 DC 2000
VTGPRE NTGPRE 0 DC 1
VMHPRE NMHPRE 0 DC 1
BSPRER SPRER 0 V = V(NMHPRE)
+ * pwl(time - V(NTIPRE), -1e4,0, 0,0, 1u,1, 150u,1, 151u,0, 300u,0, 301u,1, 450u,1, 451u,0, 520u,0, 521u,1, 1e4,1)
+ * pwl(time - V(NTRPRE), -1e4,1, 0,1, 1u,0, 400u,0, 401u,1, 600u,1, 601u,0, 1e4,0)
+ + (1 - V(NMHPRE)) * min(max((time - V(NTIPRE))/V(NTGPRE), 0), 1)
+ * (1 - min(max((time - V(NTRPRE))/V(NTGPRE), 0), 1))
RSPRE SPRER SPRE 1k
CSPRE SPRE 0 4.55n
VTISER NTISER 0 DC 1000
VTRSER NTRSER 0 DC 2000
VTGSER NTGSER 0 DC 1
VMHSER NMHSER 0 DC 1
BSSERR SSERR 0 V = V(NMHSER)
+ * pwl(time - V(NTISER), -1e4,0, 0,0, 1u,1, 150u,1, 151u,0, 300u,0, 301u,1, 450u,1, 451u,0, 520u,0, 521u,1, 1e4,1)
+ * pwl(time - V(NTRSER), -1e4,1, 0,1, 1u,0, 400u,0, 401u,1, 600u,1, 601u,0, 1e4,0)
+ + (1 - V(NMHSER)) * min(max((time - V(NTISER))/V(NTGSER), 0), 1)
+ * (1 - min(max((time - V(NTRSER))/V(NTGSER), 0), 1))
RSSER SSERR SSER 1k
CSSER SSER 0 4.55n
VTISEL NTISEL 0 DC 1000
VTRSEL NTRSEL 0 DC 2000
VTGSEL NTGSEL 0 DC 1
VMHSEL NMHSEL 0 DC 1
BSSELR SSELR 0 V = V(NMHSEL)
+ * pwl(time - V(NTISEL), -1e4,0, 0,0, 1u,1, 150u,1, 151u,0, 300u,0, 301u,1, 450u,1, 451u,0, 520u,0, 521u,1, 1e4,1)
+ * pwl(time - V(NTRSEL), -1e4,1, 0,1, 1u,0, 400u,0, 401u,1, 600u,1, 601u,0, 1e4,0)
+ + (1 - V(NMHSEL)) * min(max((time - V(NTISEL))/V(NTGSEL), 0), 1)
+ * (1 - min(max((time - V(NTRSEL))/V(NTGSEL), 0), 1))
RSSEL SSELR SSEL 1k
CSSEL SSEL 0 4.55n

* ---- selettore d'ingresso: serie, s = 1 vuol dire APERTO ----
BSEL SELA INA I = V(SELA,INA) * pow(10, -12 + 13*(1 - V(SSEL)))

* ---------------- BLOCCO A: guadagno 1, R_g non montata ------------------
VOSA INA INAX DC 0
XA INAX OUTA FBA RGA RG10A VPLUS VMINUS GAINBLOCK
RRGA RGA 0 1G
CRGA RGA 0 15p
RRG10A RG10A 0 1G
CRG10A RG10A 0 15p

* Attenuatore da 10 k: RATTT a 1 mohm = manopola al massimo.
RATTT OUTA W 1m
RATTB W 0 10k

* ---------------- BUFFER DELLE FISSE (ADR-023): guadagno 1 ---------------
VOSF1 OUTA F1IN DC 0
XF1 F1IN OUTF1 FBF1 RGF1 RG10F1 VPLUS VMINUS GAINBLOCK
RRGF1 RGF1 0 1G
CRGF1 RGF1 0 15p
RRG10F1 RG10F1 0 1G
CRG10F1 RG10F1 0 15p
VOSF2 OUTA F2IN DC 0
XF2 F2IN OUTF2 FBF2 RGF2 RG10F2 VPLUS VMINUS GAINBLOCK
RRGF2 RGF2 0 1G
CRGF2 RGF2 0 15p
RRG10F2 RG10F2 0 1G
CRG10F2 RG10F2 0 15p

RSEP1 OUTF1 FIX1 47
BPRE1 FIX1 0 I = V(FIX1) * pow(10, -12 + 13*V(SPRE))
CFIX1 FIX1 FIXC1 4.7u
RBC1 FIXC1 0 1e12
RBY1 FIXC1 FIXJACK1 1m
BSER1 FIXC1 FIXJACK1 I = V(FIXC1,FIXJACK1) * pow(10, -12 + 13*(1 - V(SSER)))
BJK1 FIXJACK1 0 I = V(FIXJACK1) * pow(10, -12 + 13*V(SJK))
RBL1 FIXJACK1 0 470k
RLD1 FIXJACK1 0 100k

RSEP2 OUTF2 FIX2 47
BPRE2 FIX2 0 I = V(FIX2) * pow(10, -12 + 13*V(SPRE))
CFIX2 FIX2 FIXC2 4.7u
RBC2 FIXC2 0 1e12
RBY2 FIXC2 FIXJACK2 1m
BSER2 FIXC2 FIXJACK2 I = V(FIXC2,FIXJACK2) * pow(10, -12 + 13*(1 - V(SSER)))
BJK2 FIXJACK2 0 I = V(FIXJACK2) * pow(10, -12 + 13*V(SJK))
RBL2 FIXJACK2 0 470k
RLD2 FIXJACK2 0 100k

* ---------------- BLOCCO B: 0 / +3 / +10 dB, due rele' su R_g ------------
* Contatto aperto = 1 G + 15 pF, chiuso = alter ... = 0.1 (ADR-026):
*   0 dB   rrgb = 1G    rrg10b = 1G
*   +3 dB  rrgb = 0.1   rrg10b = 1G
*   +10 dB rrgb = 0.1   rrg10b = 0.1
VOSB W WB DC 0
XB WB OUTB FBB RGB RG10B VPLUS VMINUS GAINBLOCK
RRGB RGB 0 1G
CRGB RGB 0 15p
RRG10B RG10B 0 1G
CRG10B RG10B 0 15p
RISOM OUTB MAIN_A 47
BPREM MAIN_A 0 I = V(MAIN_A) * pow(10, -12 + 13*V(SPRE))
COUTM MAIN_A MAINC 4.7u
RBCM MAINC 0 1e12
RBYM MAINC MAINJACK 1m
BSERM MAINC MAINJACK I = V(MAINC,MAINJACK) * pow(10, -12 + 13*(1 - V(SSER)))
BJKM MAINJACK 0 I = V(MAINJACK) * pow(10, -12 + 13*V(SJK))
RBLM MAINJACK 0 220k
RLDM MAINJACK 0 100k
* <<< CANALE
* ---- L29b2: le due LDR e il loro comando, fuori dal blocco CANALE (ADR-038) ----
VTI NTI 0 DC 1000
VTR NTR 0 DC 2000
VTD NTD 0 DC 6
BDIN DIN 0 V = min(max((time - V(NTI))/V(NTD), 0), 1)
BDEP DEP 0 V = time < V(NTR) ? V(DIN) : max(min(max((V(NTR) - V(NTI))/V(NTD), 0), 1) - (time - V(NTR))/V(NTD), 0)
* L41c: le correnti delle due stringhe LED vengono dal circuito dell'alimentatore (il ponte),
* al posto del profilo v4 per VPWL: alter @vis[pwl] / @vip[pwl] in ogni corsa
VIS NIS 0 pwl(0 0 1000 0)
VIP NIP 0 pwl(0 0 1000 0)
BILS 0 ALS I = V(NIS)
BILP 0 ALP I = V(NIP)
* 10 M dall'anodo a massa: un LED col solo generatore non ha percorso in continua e l'op
* fallisce in silenzio (trappola di L29b). E' del banco, non della scheda.
RALS ALS 0 10MEG
RALP ALP 0 10MEG
RSRC2 SRC SRCX 1.5
XLS ALS 0 SRCX SELA VTL5C4_B
XLP ALP 0 INA 0 VTL5C4_B

* ---- L29c: i contatti del guadagno, in parallelo a RRGB / RRG10B del blocco ----
* interruttore nativo: 0,1 ohm chiuso (il massimo del G6K), 1 T aperto; soglia 0,5 V sulla
* pwl 0/1 dei rimbalzi, isteresi 0,25 V
.model SWK SW(RON=0.1 ROFF=1e12 VT=0.5 VH=0.25)
VK1I NK1I 0 DC 0
VK1T NK1T 0 DC 1000
BK1R SK1R 0 V = (1 - V(NK1I)) * pwl(time - V(NK1T), -1e4,0, 0,0, 1u,1, 150u,1, 151u,0, 300u,0, 301u,1, 450u,1, 451u,0, 520u,0, 521u,1, 1e4,1)
+ + V(NK1I) * pwl(time - V(NK1T), -1e4,1, 0,1, 1u,0, 400u,0, 401u,1, 600u,1, 601u,0, 1e4,0)
SK1 RGB 0 SK1R 0 SWK
VK5I NK5I 0 DC 0
VK5T NK5T 0 DC 1000
BK5R SK5R 0 V = (1 - V(NK5I)) * pwl(time - V(NK5T), -1e4,0, 0,0, 1u,1, 150u,1, 151u,0, 300u,0, 301u,1, 450u,1, 451u,0, 520u,0, 521u,1, 1e4,1)
+ + V(NK5I) * pwl(time - V(NK5T), -1e4,1, 0,1, 1u,0, 400u,0, 401u,1, 600u,1, 601u,0, 1e4,0)
SK5 RG10B 0 SK5R 0 SWK
VK1BI NK1BI 0 DC 0
VK1BT NK1BT 0 DC 1000
BK1BR SK1BR 0 V = (1 - V(NK1BI)) * pwl(time - V(NK1BT), -1e4,0, 0,0, 1u,1, 150u,1, 151u,0, 300u,0, 301u,1, 450u,1, 451u,0, 520u,0, 521u,1, 1e4,1)
+ + V(NK1BI) * pwl(time - V(NK1BT), -1e4,1, 0,1, 1u,0, 400u,0, 401u,1, 600u,1, 601u,0, 1e4,0)
RK1BS SK1BR SK1B 1k
CK1BS SK1B 0 4.55n
BK1B RGB 0 I = V(RGB) * pow(10, -12 + 13*V(SK1B))
VK5BI NK5BI 0 DC 0
VK5BT NK5BT 0 DC 1000
BK5BR SK5BR 0 V = (1 - V(NK5BI)) * pwl(time - V(NK5BT), -1e4,0, 0,0, 1u,1, 150u,1, 151u,0, 300u,0, 301u,1, 450u,1, 451u,0, 520u,0, 521u,1, 1e4,1)
+ + V(NK5BI) * pwl(time - V(NK5BT), -1e4,1, 0,1, 1u,0, 400u,0, 401u,1, 600u,1, 601u,0, 1e4,0)
RK5BS SK5BR SK5B 1k
CK5BS SK5B 0 4.55n
BK5B RG10B 0 I = V(RG10B) * pow(10, -12 + 13*V(SK5B))
* ---- L29d: il contatto in serie al jack e la derivazione lato condensatore ----
VKSA NKSA 0 DC 1000
VKSB NKSB 0 DC 2000
BKSR NKSR 0 V = pwl(time - V(NKSA), -1e4,1, 0,1, 1u,0, 400u,0, 401u,1, 600u,1, 601u,0, 1e4,0) + pwl(time - V(NKSB), -1e4,0, 0,0, 1u,1, 150u,1, 151u,0, 300u,0, 301u,1, 450u,1, 451u,0, 520u,0, 521u,1, 1e4,1)
VKCA NKCA 0 DC 1000
VKCB NKCB 0 DC 2000
BKCR NKCR 0 V = pwl(time - V(NKCA), -1e4,0, 0,0, 1u,1, 150u,1, 151u,0, 300u,0, 301u,1, 450u,1, 451u,0, 520u,0, 521u,1, 1e4,1) + pwl(time - V(NKCB), -1e4,1, 0,1, 1u,0, 400u,0, 401u,1, 600u,1, 601u,0, 1e4,0) - 1
SKSM MAINC MAINJACK NKSR 0 SWK
CKSM MAINC MAINJACK 0.1p
SKCM MAINC 0 NKCR 0 SWK
CCAVM MAINJACK 0 1e-18
SKS1 FIXC1 FIXJACK1 NKSR 0 SWK
CKS1 FIXC1 FIXJACK1 0.1p
SKC1 FIXC1 0 NKCR 0 SWK
CCAV1 FIXJACK1 0 1e-18
SKS2 FIXC2 FIXJACK2 NKSR 0 SWK
CKS2 FIXC2 FIXJACK2 0.1p
SKC2 FIXC2 0 NKCR 0 SWK
CCAV2 FIXJACK2 0 1e-18

* ---- L29c: il trim (ADR-027, trim.py candidato 2) fra OUTA e l'attenuatore ----
* RATTT del blocco si apre nel .control (alter rattt = 1e12): OUTA arriva a W da qui.
RL1 OUTA TAP6 845
RL2 TAP6 TAP12 464
RL3 TAP12 0 464
VT1RI NT1RI 0 DC 0
VT1RT NT1RT 0 DC 1000
BT1RR ST1RR 0 V = (1 - V(NT1RI)) * pwl(time - V(NT1RT), -1e4,0, 0,0, 1u,1, 150u,1, 151u,0, 300u,0, 301u,1, 450u,1, 451u,0, 520u,0, 521u,1, 1e4,1)
+ + V(NT1RI) * pwl(time - V(NT1RT), -1e4,1, 0,1, 1u,0, 400u,0, 401u,1, 600u,1, 601u,0, 1e4,0)
ST1R OUTA ATOP ST1RR 0 SWK
CT1RP OUTA ATOP 15p
RT1RP OUTA ATOP 1G
VT1SI NT1SI 0 DC 0
VT1ST NT1ST 0 DC 1000
BT1SR ST1SR 0 V = (1 - V(NT1SI)) * pwl(time - V(NT1ST), -1e4,0, 0,0, 1u,1, 150u,1, 151u,0, 300u,0, 301u,1, 450u,1, 451u,0, 520u,0, 521u,1, 1e4,1)
+ + V(NT1SI) * pwl(time - V(NT1ST), -1e4,1, 0,1, 1u,0, 400u,0, 401u,1, 600u,1, 601u,0, 1e4,0)
ST1S T2C ATOP ST1SR 0 SWK
CT1SP T2C ATOP 15p
RT1SP T2C ATOP 1G
VT2RI NT2RI 0 DC 0
VT2RT NT2RT 0 DC 1000
BT2RR ST2RR 0 V = (1 - V(NT2RI)) * pwl(time - V(NT2RT), -1e4,0, 0,0, 1u,1, 150u,1, 151u,0, 300u,0, 301u,1, 450u,1, 451u,0, 520u,0, 521u,1, 1e4,1)
+ + V(NT2RI) * pwl(time - V(NT2RT), -1e4,1, 0,1, 1u,0, 400u,0, 401u,1, 600u,1, 601u,0, 1e4,0)
ST2R TAP6 T2C ST2RR 0 SWK
CT2RP TAP6 T2C 15p
RT2RP TAP6 T2C 1G
VT2SI NT2SI 0 DC 0
VT2ST NT2ST 0 DC 1000
BT2SR ST2SR 0 V = (1 - V(NT2SI)) * pwl(time - V(NT2ST), -1e4,0, 0,0, 1u,1, 150u,1, 151u,0, 300u,0, 301u,1, 450u,1, 451u,0, 520u,0, 521u,1, 1e4,1)
+ + V(NT2SI) * pwl(time - V(NT2ST), -1e4,1, 0,1, 1u,0, 400u,0, 401u,1, 600u,1, 601u,0, 1e4,0)
ST2S TAP12 T2C ST2SR 0 SWK
CT2SP TAP12 T2C 15p
RT2SP TAP12 T2C 1G
CWIRE ATOP 0 100p
RATTH ATOP W 1m
* ---- L29c: la sonda del gruppo B (limitations #29), su nodi propri (#24) ----
VPRBD PRBD 0 DC 15
VPRBG PRBG 0 DC 0
JPRB PRBD PRBG 0 LSK489A
* ---- L29c: l'alimentazione del comando dei LED, 0..1, segue il rail positivo ----
VPWL NPWL 0 DC 1
* ---- L29c: il punto di partenza di Newton per l'op (limitations #33) ----
* Con l'interruttore del trim fra OUTA e W il blocco A ha una seconda soluzione in continua,
* agganciata al rail (+13 V): gmin e source stepping falliscono e il 'transient op' finisce
* li', 'successfully'. Il nodeset e' solo il primo tentativo di Newton: la soluzione resta
* una soluzione del circuito, e ridà quella del deck di main (sonde/op/, controfattuale).
.nodeset V(OUTA)=0 V(W)=0 V(ATOP)=0 V(OUTB)=0 V(MAIN_A)=0 V(OUTF1)=0 V(OUTF2)=0

.control
* limitations #30: il tempo a 16 cifre, prima di ogni wrdata
set numdgt=15
set d = .dat
* L29c: corri.sh rifiuta ogni corsa col 'Transient op' nel log (limitations #33).
save v(mainjack) v(fixjack1) v(fixjack2) v(xls.xs) v(xlp.xs) v(dep) v(ina) v(vplus) v(vminus) v(main_a) v(mainc) v(fixc1) v(fixc2)
echo "cella,file,variante,f_hz,amp,gm,rl,t_ins,t_rel,t_fine,tmax,tipo,rif_ins,rif_rel,t_grad,gruppo,conta" > tb_v2_casopeggiore_manifest.csv
* la sorgente passa dalla LDR in serie: RSRC del blocco a 1 T, il selettore chiuso
alter rsrc = 1e12
alter vphs dc = 1.5707963267948966
alter vmhjk dc = 1
* il trim porta OUTA all'attenuatore: RATTT del blocco aperto
alter rattt = 1e12
* ---- L41c: rif_spegnimento_l_l41c (dal ponte: spegnimento_l, giro 2) ----
alter vamp dc = 0
alter vfrq dc = 1000
alter rldm = 100k
alter rld1 = 100k
alter rld2 = 100k
alter vti dc = 1000
alter vtr dc = 2000
alter vtijk dc = 1000
alter vtrjk dc = 1000
alter vosa dc = 0
alter vosb dc = 0
alter vosf1 dc = 0
alter vosf2 dc = 0
alter ratth = 1m
alter rattb = 10k
alter rl1 = 845
alter cwire = 100p
alter vk1bi dc = 1
alter vk1bt dc = 1000.000000
alter vk5bi dc = 1
alter vk5bt dc = 1000.000000
alter vk1i dc = 0
alter vk1t dc = 1000.000000
alter vk5i dc = 0
alter vk5t dc = 1000.000000
alter vt1ri dc = 1
alter vt1rt dc = 1000.000000
alter vt1si dc = 0
alter vt1st dc = 1000.000000
alter vt2ri dc = 1
alter vt2rt dc = 1000.000000
alter vt2si dc = 0
alter vt2st dc = 1000.000000
alter vtijk dc = 1000.000000
alter vtrjk dc = 2000.000000
alter vksa dc = 1000.000000
alter vksb dc = 1000.001000
alter vkca dc = 1000.001000
alter vkcb dc = 1000.000000
alter vtiser dc = -10
alter vtrser dc = 1000
alter rbym = 1e12
alter rby1 = 1e12
alter rby2 = 1e12
alter rbcm = 220k
alter rbc1 = 470k
alter rbc2 = 470k
alter cksm = 0.1p
alter cks1 = 0.1p
alter cks2 = 0.1p
alter ccavm = 1e-18
alter ccav1 = 1e-18
alter ccav2 = 1e-18
print @cksm[capacitance] @cks1[capacitance] @cks2[capacitance] @ccavm[capacitance] @ccav1[capacitance] @ccav2[capacitance]
alter @vpp[pwl] = [ 0.000100000 14.999735 1.000000000 14.999735 2.200000000 14.999735 ]
alter @vmm[pwl] = [ 0.000100000 -15.052534 1.000000000 -15.052534 2.200000000 -15.052534 ]
alter @vpwl[pwl] = [ 0 1 1000 1 ]
alter @vis[pwl] = [ 0.000100000 1.226124e-08 1.000000000 1.226117e-08 2.200000000 1.226117e-08 ]
alter @vip[pwl] = [ 0.000100000 5.857040e-04 0.036000000 6.917856e-04 0.067000000 7.993146e-04 0.123000000 1.037299e-03 0.177000000 1.333851e-03 0.223000000 1.652522e-03 0.269000000 2.047349e-03 0.313000000 2.513706e-03 0.355000000 3.058561e-03 0.391000000 3.619064e-03 0.425000000 4.242160e-03 0.456000000 4.903948e-03 0.516000000 6.497450e-03 0.576000000 8.613412e-03 0.635300000 1.133309e-02 0.660900000 1.184730e-02 0.723400000 1.201087e-02 1.000000000 1.201381e-02 2.200000000 1.201381e-02 ]
tran 1e-05 2.1999999999910003 0 1e-05
wrdata rif_spegnimento_l_l41c$d v(mainjack) v(fixjack1) v(fixjack2)
wrdata rif_spegnimento_l_l41c_stati$d v(xls.xs) v(xlp.xs) v(dep) v(ina) v(vplus) v(vminus) v(main_a) v(mainc) v(fixc1) v(fixc2)
destroy all
echo "rif_spegnimento_l_l41c,rif_spegnimento_l_l41c.dat,rif,1000,0,10,100k,1.000000000,1000,2.1999999999910003,1e-05,rif_mai,-,-,0.0,0," >> tb_v2_casopeggiore_manifest.csv
* ---- L41c: spegnimento_l_l41c (dal ponte: spegnimento_l, giro 2) ----
alter vamp dc = 0
alter vfrq dc = 1000
alter rldm = 100k
alter rld1 = 100k
alter rld2 = 100k
alter vti dc = 1000
alter vtr dc = 2000
alter vtijk dc = 1.1322999999930001
alter vtrjk dc = 1000
alter vosa dc = 0
alter vosb dc = 0
alter vosf1 dc = 0
alter vosf2 dc = 0
alter ratth = 1m
alter rattb = 10k
alter rl1 = 845
alter cwire = 100p
alter vk1bi dc = 1
alter vk1bt dc = 1.169100
alter vk5bi dc = 1
alter vk5bt dc = 1.169400
alter vk1i dc = 0
alter vk1t dc = 1000.000000
alter vk5i dc = 0
alter vk5t dc = 1000.000000
alter vt1ri dc = 1
alter vt1rt dc = 1000.000000
alter vt1si dc = 0
alter vt1st dc = 1000.000000
alter vt2ri dc = 1
alter vt2rt dc = 1000.000000
alter vt2si dc = 0
alter vt2st dc = 1000.000000
alter vtijk dc = 1000.000000
alter vtrjk dc = 2000.000000
alter vksa dc = 1.132300
alter vksb dc = 1000.001000
alter vkca dc = 1.133300
alter vkcb dc = 1000.000000
alter vtiser dc = -10
alter vtrser dc = 1000
alter rbym = 1e12
alter rby1 = 1e12
alter rby2 = 1e12
alter rbcm = 220k
alter rbc1 = 470k
alter rbc2 = 470k
alter cksm = 0.1p
alter cks1 = 0.1p
alter cks2 = 0.1p
alter ccavm = 1e-18
alter ccav1 = 1e-18
alter ccav2 = 1e-18
print @cksm[capacitance] @cks1[capacitance] @cks2[capacitance] @ccavm[capacitance] @ccav1[capacitance] @ccav2[capacitance]
alter @vpp[pwl] = [ 0.000100000 14.999735 1.304400000 14.999735 1.304500000 14.997386 1.304600000 14.992914 1.309800000 14.745713 1.314900000 14.507119 1.319100000 14.313524 1.323400000 14.117990 1.328000000 13.911764 1.332600000 13.708543 1.337200000 13.508284 1.341800000 13.310943 1.346500000 13.112283 1.351300000 12.912448 1.356000000 12.719720 1.360800000 12.525853 1.365600000 12.334933 1.370400000 12.146915 1.375300000 11.957928 1.380200000 11.771874 1.385100000 11.588707 1.390100000 11.404731 1.395100000 11.223667 1.400100000 11.045470 1.405100000 10.870093 1.410200000 10.694069 1.415300000 10.520887 1.420400000 10.350501 1.425500000 10.182866 1.430700000 10.014730 1.435900000 9.849361 1.441200000 9.683613 1.446400000 9.523694 1.451700000 9.363408 1.457000000 9.205810 1.462400000 9.047957 1.467800000 8.892801 1.473200000 8.740296 1.478600000 8.590397 1.484100000 8.440355 1.489600000 8.292923 1.495100000 8.148057 1.500700000 8.003146 1.506300000 7.860802 1.511900000 7.720979 1.517600000 7.581203 1.523300000 7.443946 1.529100000 7.306821 1.534900000 7.172211 1.540700000 7.040070 1.546500000 6.910352 1.552400000 6.780839 1.558300000 6.653741 1.564300000 6.526920 1.570300000 6.402505 1.576300000 6.280449 1.582400000 6.158732 1.588500000 6.039361 1.594700000 5.920392 1.600900000 5.803754 1.607100000 5.689401 1.613400000 5.575498 1.619700000 5.463863 1.626100000 5.352730 1.632500000 5.243845 1.639000000 5.135511 1.645500000 5.029402 1.652000000 4.925471 1.658500000 4.823674 1.665100000 4.722448 1.671700000 4.623333 1.678400000 4.524829 1.685100000 4.428409 1.691900000 4.332635 1.698700000 4.238918 1.705500000 4.147212 1.712400000 4.056170 1.719300000 3.967110 1.726300000 3.878742 1.733400000 3.791106 1.740500000 3.705433 1.747700000 3.620514 1.754900000 3.537523 1.762200000 3.455305 1.769500000 3.374979 1.776900000 3.295442 1.784400000 3.216723 1.791900000 3.139866 1.799500000 3.063839 1.807100000 2.989633 1.814800000 2.916264 1.822500000 2.844677 1.830300000 2.773931 1.838200000 2.704051 1.846200000 2.635059 1.854200000 2.567806 1.862300000 2.501440 1.870500000 2.435980 1.878700000 2.372210 1.887000000 2.309340 1.895400000 2.247385 1.903800000 2.187070 1.912300000 2.127660 1.920900000 2.069169 1.929600000 2.011610 1.938300000 1.955626 1.947200000 1.899942 1.956100000 1.845816 1.965100000 1.792624 1.974200000 1.740372 1.983400000 1.689067 1.992600000 1.639245 2.002000000 1.589830 2.011400000 1.541874 2.021000000 1.494361 2.030600000 1.448281 2.040300000 1.403134 2.050200000 1.358474 2.060100000 1.315204 2.070200000 1.272446 2.080300000 1.231044 2.090600000 1.190174 2.101000000 1.150249 2.111500000 1.111261 2.122100000 1.073206 2.132900000 1.035734 2.143700000 0.999532 2.154700000 0.963919 2.165800000 0.929229 2.177100000 0.895153 2.188500000 0.861999 2.200000000 0.829753 ]
alter @vmm[pwl] = [ 0.000100000 -15.052534 1.303200000 -15.052534 1.303300000 -15.050821 1.303400000 -15.046404 1.308800000 -14.788502 1.311400000 -14.665841 1.314100000 -14.539535 1.318300000 -14.345209 1.322500000 -14.153470 1.327000000 -13.950867 1.331600000 -13.746746 1.336200000 -13.545600 1.340800000 -13.347385 1.345500000 -13.147844 1.350300000 -12.947122 1.355000000 -12.753539 1.359800000 -12.558811 1.364600000 -12.367043 1.369400000 -12.178189 1.374300000 -11.988362 1.379200000 -11.801480 1.384100000 -11.617496 1.389100000 -11.432701 1.394100000 -11.250830 1.399100000 -11.071838 1.404100000 -10.895679 1.409200000 -10.718868 1.414300000 -10.544912 1.419400000 -10.373764 1.424500000 -10.205379 1.429700000 -10.036491 1.434900000 -9.870381 1.440200000 -9.703890 1.445400000 -9.543254 1.450700000 -9.382248 1.456000000 -9.223943 1.461400000 -9.065380 1.466800000 -8.909527 1.472200000 -8.756336 1.477600000 -8.605762 1.483100000 -8.455044 1.488600000 -8.306948 1.494200000 -8.158806 1.499800000 -8.013287 1.505400000 -7.870346 1.511000000 -7.729936 1.516700000 -7.589573 1.522400000 -7.451739 1.528200000 -7.314038 1.534000000 -7.178861 1.539800000 -7.046163 1.545600000 -6.915898 1.551500000 -6.785838 1.557400000 -6.658204 1.563400000 -6.530847 1.569400000 -6.405905 1.575400000 -6.283333 1.581500000 -6.161101 1.587600000 -6.041225 1.593800000 -5.921751 1.600000000 -5.804618 1.606300000 -5.687945 1.612600000 -5.573595 1.618900000 -5.461520 1.625300000 -5.349951 1.631700000 -5.240636 1.638200000 -5.131875 1.644700000 -5.025347 1.651200000 -4.921005 1.657700000 -4.818806 1.664300000 -4.717180 1.670900000 -4.617672 1.677600000 -4.518778 1.684300000 -4.421975 1.691100000 -4.325821 1.697900000 -4.231731 1.704700000 -4.139661 1.711600000 -4.048256 1.718600000 -3.957561 1.725600000 -3.868868 1.732700000 -3.780910 1.739800000 -3.694923 1.747000000 -3.609691 1.754200000 -3.526395 1.761500000 -3.443873 1.768800000 -3.363251 1.776200000 -3.283420 1.783700000 -3.204410 1.791200000 -3.127269 1.798800000 -3.050959 1.806400000 -2.976479 1.814100000 -2.902837 1.821900000 -2.830062 1.829700000 -2.759076 1.837600000 -2.688958 1.845600000 -2.619731 1.853600000 -2.552248 1.861700000 -2.485655 1.869900000 -2.419971 1.878200000 -2.355213 1.886500000 -2.292147 1.894900000 -2.230000 1.903300000 -2.169496 1.911900000 -2.109209 1.920500000 -2.050554 1.929200000 -1.992833 1.937900000 -1.936691 1.946800000 -1.880850 1.955700000 -1.826572 1.964700000 -1.773229 1.973800000 -1.720829 1.983000000 -1.669378 1.992300000 -1.618879 2.001700000 -1.569339 2.011100000 -1.521262 2.020700000 -1.473628 2.030300000 -1.427431 2.040000000 -1.382169 2.049900000 -1.337395 2.059800000 -1.294014 2.069900000 -1.251146 2.080100000 -1.209233 2.090400000 -1.168272 2.100800000 -1.128256 2.111300000 -1.089180 2.121900000 -1.051038 2.132700000 -1.013481 2.143600000 -0.976866 2.154600000 -0.941184 2.165700000 -0.906425 2.177000000 -0.872281 2.188400000 -0.839061 2.200000000 -0.806476 ]
alter @vpwl[pwl] = [ 0 1 1000 1 ]
alter @vis[pwl] = [ 0.000100000 1.226124e-08 1.229000000 1.226115e-08 1.232600000 1.035290e-08 1.236900000 8.833186e-09 1.242000000 7.666480e-09 1.248300000 6.767071e-09 1.265300000 5.661801e-09 1.293200000 5.167490e-09 2.200000000 5.023841e-09 ]
alter @vip[pwl] = [ 0.000100000 5.857040e-04 0.036000000 6.917856e-04 0.067000000 7.993146e-04 0.123000000 1.037299e-03 0.177000000 1.333851e-03 0.223000000 1.652522e-03 0.269000000 2.047349e-03 0.313000000 2.513706e-03 0.355000000 3.058561e-03 0.391000000 3.619064e-03 0.425000000 4.242160e-03 0.456000000 4.903948e-03 0.516000000 6.497450e-03 0.576000000 8.613412e-03 0.635300000 1.133309e-02 0.660900000 1.184730e-02 0.723400000 1.201087e-02 1.229000000 1.201624e-02 1.229300000 1.000710e-02 1.229600000 8.282593e-03 1.229900000 6.833949e-03 1.230300000 5.270491e-03 1.230700000 4.055302e-03 1.231100000 3.117947e-03 1.231500000 2.398585e-03 1.231700000 2.104911e-03 1.232000000 1.732125e-03 1.232200000 1.522245e-03 1.232500000 1.255848e-03 1.232700000 1.105792e-03 1.233000000 9.151354e-04 1.233300000 7.589398e-04 1.233600000 6.307657e-04 1.234000000 4.946306e-04 1.234400000 3.894893e-04 1.234800000 3.079972e-04 1.235000000 2.743262e-04 1.235300000 2.310575e-04 1.235500000 2.063495e-04 1.235800000 1.745016e-04 1.236300000 1.326695e-04 1.236600000 1.129097e-04 1.237000000 9.139653e-05 1.237300000 7.820997e-05 1.237700000 6.376642e-05 1.238100000 5.220027e-05 1.238500000 4.290185e-05 1.239000000 3.375655e-05 1.239500000 2.671947e-05 1.239900000 2.225492e-05 1.240300000 1.860436e-05 1.240800000 1.494639e-05 1.241300000 1.207349e-05 1.241900000 9.411207e-06 1.242500000 7.390935e-06 1.242800000 6.567685e-06 1.243200000 5.626470e-06 1.243900000 4.324214e-06 1.244300000 3.735764e-06 1.244700000 3.236913e-06 1.245200000 2.716948e-06 1.245700000 2.290570e-06 1.246200000 1.939416e-06 1.246800000 1.597138e-06 1.247400000 1.322997e-06 1.248000000 1.102165e-06 1.248700000 8.969008e-07 1.249400000 7.351913e-07 1.250300000 5.752530e-07 1.251200000 4.551478e-07 1.252200000 3.552796e-07 1.252800000 3.080747e-07 1.253400000 2.683185e-07 1.254100000 2.296085e-07 1.254800000 1.975932e-07 1.255600000 1.675463e-07 1.256400000 1.430473e-07 1.257300000 1.206904e-07 1.258200000 1.026493e-07 1.259200000 8.652646e-08 1.260400000 7.133423e-08 1.261700000 5.868444e-08 1.263100000 4.829088e-08 1.264700000 3.935419e-08 1.266400000 3.229239e-08 1.268300000 2.646422e-08 1.270500000 2.157670e-08 1.273000000 1.763813e-08 1.276000000 1.437270e-08 1.279400000 1.187648e-08 1.283500000 9.892348e-09 1.288400000 8.379189e-09 1.294500000 7.222680e-09 1.304300000 6.211999e-09 1.317500000 5.581419e-09 1.364400000 5.071554e-09 2.200000000 5.023840e-09 ]
tran 1e-05 2.1999999999910003 0 1e-05
wrdata spegnimento_l_l41c$d v(mainjack) v(fixjack1) v(fixjack2)
wrdata spegnimento_l_l41c_stati$d v(xls.xs) v(xlp.xs) v(dep) v(ina) v(vplus) v(vminus) v(main_a) v(mainc) v(fixc1) v(fixc2)
destroy all
echo "spegnimento_l_l41c,spegnimento_l_l41c.dat,l41c_spegnimento_l,1000,0,10a0,100k,1.000000000,1000,2.1999999999910003,1e-05,evento,rif_spegnimento_l_l41c,-,0.0,6,A_ins" >> tb_v2_casopeggiore_manifest.csv
* ---- L41c: rif_perdita_l41c (dal ponte: perdita, giro 3) ----
alter vamp dc = 0
alter vfrq dc = 1000
alter rldm = 100k
alter rld1 = 100k
alter rld2 = 100k
alter vti dc = 1000
alter vtr dc = 2000
alter vtijk dc = 1000
alter vtrjk dc = 1000
alter vosa dc = 0
alter vosb dc = 0
alter vosf1 dc = 0
alter vosf2 dc = 0
alter ratth = 1m
alter rattb = 10k
alter rl1 = 845
alter cwire = 100p
alter vk1bi dc = 1
alter vk1bt dc = 1000.000000
alter vk5bi dc = 1
alter vk5bt dc = 1000.000000
alter vk1i dc = 0
alter vk1t dc = 1000.000000
alter vk5i dc = 0
alter vk5t dc = 1000.000000
alter vt1ri dc = 1
alter vt1rt dc = 1000.000000
alter vt1si dc = 0
alter vt1st dc = 1000.000000
alter vt2ri dc = 1
alter vt2rt dc = 1000.000000
alter vt2si dc = 0
alter vt2st dc = 1000.000000
alter vtijk dc = 1000.000000
alter vtrjk dc = 2000.000000
alter vksa dc = 1000.000000
alter vksb dc = 1000.001000
alter vkca dc = 1000.001000
alter vkcb dc = 1000.000000
alter vtiser dc = -10
alter vtrser dc = 1000
alter rbym = 1e12
alter rby1 = 1e12
alter rby2 = 1e12
alter rbcm = 220k
alter rbc1 = 470k
alter rbc2 = 470k
alter cksm = 0.1p
alter cks1 = 0.1p
alter cks2 = 0.1p
alter ccavm = 1e-18
alter ccav1 = 1e-18
alter ccav2 = 1e-18
print @cksm[capacitance] @cks1[capacitance] @cks2[capacitance] @ccavm[capacitance] @ccav1[capacitance] @ccav2[capacitance]
alter @vpp[pwl] = [ 0.000100000 14.999735 0.990000000 14.999735 2.000000000 14.999735 ]
alter @vmm[pwl] = [ 0.000100000 -15.052534 0.990000000 -15.052534 2.000000000 -15.052534 ]
alter @vpwl[pwl] = [ 0 1 1000 1 ]
alter @vis[pwl] = [ 0.000100000 1.201624e-02 0.990000000 1.201626e-02 2.000000000 1.201626e-02 ]
alter @vip[pwl] = [ 0.000100000 1.226115e-08 0.990000000 1.226117e-08 2.000000000 1.226117e-08 ]
tran 1e-05 2.000000000002 0 1e-05
wrdata rif_perdita_l41c$d v(mainjack) v(fixjack1) v(fixjack2)
wrdata rif_perdita_l41c_stati$d v(xls.xs) v(xlp.xs) v(dep) v(ina) v(vplus) v(vminus) v(main_a) v(mainc) v(fixc1) v(fixc2)
destroy all
echo "rif_perdita_l41c,rif_perdita_l41c.dat,rif,1000,0,10,100k,0.990000000,1000,2.000000000002,1e-05,rif_mai,-,-,0.0,0," >> tb_v2_casopeggiore_manifest.csv
* ---- L41c: perdita_l41c (dal ponte: perdita, giro 3) ----
alter vamp dc = 0
alter vfrq dc = 1000
alter rldm = 100k
alter rld1 = 100k
alter rld2 = 100k
alter vti dc = 1000
alter vtr dc = 2000
alter vtijk dc = 1.0174000000000003
alter vtrjk dc = 1000
alter vosa dc = 0
alter vosb dc = 0
alter vosf1 dc = 0
alter vosf2 dc = 0
alter ratth = 1m
alter rattb = 10k
alter rl1 = 845
alter cwire = 100p
alter vk1bi dc = 1
alter vk1bt dc = 1.034700
alter vk5bi dc = 1
alter vk5bt dc = 1.035000
alter vk1i dc = 0
alter vk1t dc = 1000.000000
alter vk5i dc = 0
alter vk5t dc = 1000.000000
alter vt1ri dc = 1
alter vt1rt dc = 1000.000000
alter vt1si dc = 0
alter vt1st dc = 1000.000000
alter vt2ri dc = 1
alter vt2rt dc = 1000.000000
alter vt2si dc = 0
alter vt2st dc = 1000.000000
alter vtijk dc = 1000.000000
alter vtrjk dc = 2000.000000
alter vksa dc = 1.017400
alter vksb dc = 1000.001000
alter vkca dc = 1.018400
alter vkcb dc = 1000.000000
alter vtiser dc = -10
alter vtrser dc = 1000
alter rbym = 1e12
alter rby1 = 1e12
alter rby2 = 1e12
alter rbcm = 220k
alter rbc1 = 470k
alter rbc2 = 470k
alter cksm = 0.1p
alter cks1 = 0.1p
alter cks2 = 0.1p
alter ccavm = 1e-18
alter ccav1 = 1e-18
alter ccav2 = 1e-18
print @cksm[capacitance] @cks1[capacitance] @cks2[capacitance] @ccavm[capacitance] @ccav1[capacitance] @ccav2[capacitance]
alter @vpp[pwl] = [ 0.000100000 14.999735 1.074400000 14.999735 1.074500000 14.997391 1.074600000 14.992915 1.079900000 14.740998 1.082500000 14.618915 1.085100000 14.497841 1.089400000 14.299795 1.093800000 14.099937 1.098500000 13.889530 1.103200000 13.682256 1.107900000 13.478067 1.112600000 13.276918 1.117400000 13.074580 1.122200000 12.875318 1.127100000 12.675029 1.132000000 12.477848 1.136900000 12.283726 1.141800000 12.092617 1.146800000 11.900664 1.151800000 11.711749 1.156800000 11.525825 1.161900000 11.339215 1.167000000 11.155617 1.172100000 10.974983 1.177200000 10.797266 1.182400000 10.619018 1.187600000 10.443703 1.192900000 10.267986 1.198200000 10.095217 1.203500000 9.925345 1.208800000 9.758322 1.214200000 9.591028 1.219600000 9.426593 1.225000000 9.264968 1.230400000 9.106104 1.235900000 8.947089 1.241400000 8.790840 1.246900000 8.637310 1.252500000 8.483732 1.258100000 8.332876 1.263700000 8.184691 1.269400000 8.036555 1.275100000 7.891090 1.280900000 7.745765 1.286700000 7.603104 1.292500000 7.463060 1.298400000 7.323237 1.304300000 7.186021 1.310200000 7.051365 1.316200000 6.917003 1.322200000 6.785189 1.328200000 6.655875 1.334300000 6.526920 1.340400000 6.400451 1.346600000 6.274407 1.352800000 6.150833 1.359000000 6.029680 1.365300000 5.909004 1.371600000 5.790730 1.378000000 5.672989 1.384400000 5.557628 1.390900000 5.442852 1.397400000 5.330433 1.403900000 5.220321 1.410500000 5.110829 1.417200000 5.002011 1.423900000 4.895496 1.430600000 4.791234 1.437300000 4.689178 1.444100000 4.587806 1.450900000 4.488610 1.457700000 4.391544 1.464600000 4.295180 1.471600000 4.199564 1.478600000 4.106061 1.485700000 4.013331 1.492800000 3.922680 1.500000000 3.832825 1.507200000 3.745012 1.514500000 3.658015 1.521800000 3.573022 1.529200000 3.488861 1.536700000 3.405568 1.544200000 3.324245 1.551800000 3.243799 1.559400000 3.165281 1.567100000 3.087648 1.574800000 3.011900 1.582600000 2.937043 1.590500000 2.863102 1.598500000 2.790101 1.606500000 2.718940 1.614600000 2.648717 1.622800000 2.579452 1.631000000 2.511976 1.639300000 2.445452 1.647700000 2.379898 1.656100000 2.316077 1.664700000 2.252485 1.673300000 2.190615 1.682000000 2.129730 1.690700000 2.070511 1.699600000 2.011610 1.708500000 1.954357 1.717500000 1.898092 1.726600000 1.842821 1.735800000 1.788551 1.745000000 1.735851 1.754400000 1.683580 1.763800000 1.632854 1.773400000 1.582596 1.783000000 1.533854 1.792700000 1.486098 1.802600000 1.438858 1.812500000 1.393087 1.822600000 1.347859 1.832700000 1.304065 1.843000000 1.260834 1.853400000 1.218601 1.863900000 1.177362 1.874500000 1.137107 1.885300000 1.097470 1.896100000 1.059177 1.907100000 1.021507 1.918200000 0.984812 1.929500000 0.948767 1.940900000 0.913697 1.952400000 0.879589 1.964100000 0.846149 1.975900000 0.813664 1.987900000 0.781860 2.000000000 0.751000 ]
alter @vmm[pwl] = [ 0.000100000 -15.052534 1.073200000 -15.052534 1.073300000 -15.050822 1.073400000 -15.046405 1.076300000 -14.907410 1.078900000 -14.783766 1.081500000 -14.661144 1.084200000 -14.534878 1.088500000 -14.336020 1.092800000 -14.139872 1.097400000 -13.932998 1.102100000 -13.724740 1.106800000 -13.519581 1.111500000 -13.317476 1.116300000 -13.114177 1.121100000 -12.913967 1.126000000 -12.712725 1.130900000 -12.514604 1.135800000 -12.319558 1.140800000 -12.123650 1.145800000 -11.930842 1.150800000 -11.741087 1.155800000 -11.554335 1.160900000 -11.366893 1.166000000 -11.182476 1.171100000 -11.001037 1.176200000 -10.822526 1.181400000 -10.643481 1.186600000 -10.467383 1.191900000 -10.290880 1.197200000 -10.117337 1.202500000 -9.946705 1.207800000 -9.778933 1.213200000 -9.610890 1.218600000 -9.445717 1.224000000 -9.283366 1.229400000 -9.123789 1.234900000 -8.964058 1.240400000 -8.807107 1.246000000 -8.650107 1.251600000 -8.495887 1.257200000 -8.344399 1.262800000 -8.195593 1.268500000 -8.046837 1.274200000 -7.900762 1.280000000 -7.754826 1.285800000 -7.611566 1.291600000 -7.470934 1.297500000 -7.330522 1.303400000 -7.192729 1.309300000 -7.057506 1.315300000 -6.922577 1.321300000 -6.790207 1.327300000 -6.660347 1.333400000 -6.530847 1.339500000 -6.403843 1.345700000 -6.277266 1.351900000 -6.153169 1.358200000 -6.029559 1.364500000 -5.908410 1.370800000 -5.789672 1.377200000 -5.671468 1.383600000 -5.555655 1.390100000 -5.440427 1.396600000 -5.327565 1.403100000 -5.217020 1.409700000 -5.107095 1.416400000 -4.997848 1.423100000 -4.890912 1.429800000 -4.786238 1.436500000 -4.683778 1.443300000 -4.582004 1.450100000 -4.482415 1.456900000 -4.384964 1.463800000 -4.288217 1.470800000 -4.192221 1.477800000 -4.098346 1.484900000 -4.005247 1.492000000 -3.914234 1.499200000 -3.824021 1.506400000 -3.735857 1.513700000 -3.648512 1.521100000 -3.562024 1.528500000 -3.477553 1.536000000 -3.393953 1.543500000 -3.312329 1.551100000 -3.231586 1.558700000 -3.152778 1.566400000 -3.074857 1.574200000 -2.997853 1.582000000 -2.922742 1.589900000 -2.848550 1.597900000 -2.775301 1.605900000 -2.703897 1.614000000 -2.633435 1.622200000 -2.563934 1.630500000 -2.495413 1.638800000 -2.428683 1.647200000 -2.362924 1.655600000 -2.298905 1.664200000 -2.235115 1.672800000 -2.173052 1.681500000 -2.111977 1.690200000 -2.052574 1.699100000 -1.993489 1.708000000 -1.936059 1.717000000 -1.879619 1.726100000 -1.824177 1.735300000 -1.769738 1.744600000 -1.716309 1.754000000 -1.663893 1.763400000 -1.613026 1.773000000 -1.562629 1.782600000 -1.513752 1.792300000 -1.465864 1.802200000 -1.418493 1.812200000 -1.372140 1.822300000 -1.326801 1.832500000 -1.282473 1.842800000 -1.239151 1.853200000 -1.196829 1.863700000 -1.155503 1.874300000 -1.115164 1.885100000 -1.075444 1.896000000 -1.036720 1.907000000 -0.998984 1.918100000 -0.962224 1.929400000 -0.926116 1.940800000 -0.890984 1.952400000 -0.856524 1.964100000 -0.823036 1.975900000 -0.790505 1.987900000 -0.758655 2.000000000 -0.727752 ]
alter @vpwl[pwl] = [ 0 1 1000 1 ]
alter @vis[pwl] = [ 0.000100000 1.201624e-02 1.014300000 1.201626e-02 1.014400000 1.159833e-02 1.014700000 9.626439e-03 1.015000000 7.961844e-03 1.015300000 6.567494e-03 1.015600000 5.407243e-03 1.016000000 4.165964e-03 1.016400000 3.208388e-03 1.016800000 2.473216e-03 1.017000000 2.172939e-03 1.017300000 1.791561e-03 1.017500000 1.576696e-03 1.017800000 1.303750e-03 1.018100000 1.080250e-03 1.018400000 8.970300e-04 1.018700000 7.466135e-04 1.019000000 6.229174e-04 1.019400000 4.911551e-04 1.019800000 3.890109e-04 1.020200000 3.095166e-04 1.020400000 2.765606e-04 1.020700000 2.340894e-04 1.021200000 1.783103e-04 1.021500000 1.519597e-04 1.021800000 1.298305e-04 1.022100000 1.112015e-04 1.022500000 9.080141e-05 1.022800000 7.821951e-05 1.023200000 6.435292e-05 1.023600000 5.316755e-05 1.024000000 4.410793e-05 1.024500000 3.512135e-05 1.025000000 2.813870e-05 1.025400000 2.366861e-05 1.025900000 1.916707e-05 1.026400000 1.561092e-05 1.026900000 1.278573e-05 1.027500000 1.013425e-05 1.028100000 8.093714e-06 1.028500000 6.995645e-06 1.028900000 6.065864e-06 1.029300000 5.276097e-06 1.029700000 4.603190e-06 1.030100000 4.028122e-06 1.030600000 3.423255e-06 1.031100000 2.922176e-06 1.031600000 2.505256e-06 1.032200000 2.094288e-06 1.032800000 1.761039e-06 1.033400000 1.489254e-06 1.034100000 1.233241e-06 1.034900000 1.002883e-06 1.035700000 8.229388e-07 1.036600000 6.656167e-07 1.037700000 5.208639e-07 1.038800000 4.136118e-07 1.039400000 3.668841e-07 1.040100000 3.206043e-07 1.040800000 2.816290e-07 1.041600000 2.443505e-07 1.042400000 2.133447e-07 1.043300000 1.844626e-07 1.044300000 1.582749e-07 1.045400000 1.350594e-07 1.046600000 1.148604e-07 1.048000000 9.638397e-08 1.049500000 8.108860e-08 1.051100000 6.851730e-08 1.052900000 5.771102e-08 1.055000000 4.826894e-08 1.057300000 4.064331e-08 1.059900000 3.434875e-08 1.062900000 2.913546e-08 1.066300000 2.496505e-08 1.070300000 2.156912e-08 1.075000000 1.887916e-08 1.080600000 1.678274e-08 1.087400000 1.518397e-08 1.095700000 1.402212e-08 1.106100000 1.321767e-08 1.137400000 1.242448e-08 1.408100000 1.225896e-08 1.469100000 8.995336e-09 1.537300000 6.074813e-09 1.607600000 3.705473e-09 1.659900000 2.352940e-09 1.671800000 2.196439e-09 1.675200000 3.005582e-09 1.678200000 4.018722e-09 1.681000000 5.307878e-09 1.683500000 6.829268e-09 1.685700000 8.534414e-09 1.687900000 1.063804e-08 1.692800000 1.663375e-08 1.711900000 2.731712e-08 1.731200000 3.972755e-08 1.748300000 5.231478e-08 1.764200000 6.575481e-08 1.781300000 8.249959e-08 1.797600000 1.010607e-07 1.836700000 1.544790e-07 1.847700000 1.614939e-07 1.853800000 1.589301e-07 1.860500000 1.510302e-07 1.888000000 9.884088e-08 1.897700000 8.189941e-08 1.910600000 6.304730e-08 1.924100000 4.762662e-08 1.931700000 4.062513e-08 1.939700000 3.436269e-08 1.948100000 2.883633e-08 1.957100000 2.391997e-08 1.966600000 1.966447e-08 1.976900000 1.593238e-08 1.988000000 1.273138e-08 2.000000000 1.002208e-08 ]
alter @vip[pwl] = [ 0.000100000 1.226115e-08 1.014300000 1.226117e-08 1.014400000 1.275723e-08 1.014700000 1.557417e-08 1.015100000 2.041053e-08 1.015500000 2.681500e-08 1.015900000 3.523889e-08 1.016200000 4.321651e-08 1.016400000 4.948054e-08 1.016700000 6.053770e-08 1.016900000 6.917772e-08 1.017300000 9.007508e-08 1.017700000 1.167940e-07 1.018100000 1.507560e-07 1.018400000 1.820006e-07 1.018800000 2.329718e-07 1.019100000 2.794696e-07 1.019400000 3.343236e-07 1.019700000 3.988419e-07 1.020200000 5.319522e-07 1.020700000 7.041485e-07 1.021200000 9.251833e-07 1.021700000 1.206771e-06 1.022100000 1.484938e-06 1.022500000 1.819051e-06 1.022900000 2.218563e-06 1.023300000 2.694181e-06 1.023600000 3.108044e-06 1.024000000 3.746768e-06 1.024300000 4.299035e-06 1.024700000 5.145993e-06 1.025000000 5.873840e-06 1.025600000 7.603472e-06 1.026200000 9.759918e-06 1.026700000 1.194261e-05 1.027200000 1.453316e-05 1.027700000 1.759106e-05 1.028200000 2.118152e-05 1.028700000 2.537557e-05 1.029500000 3.353568e-05 1.030200000 4.237744e-05 1.030900000 5.307379e-05 1.031600000 6.590017e-05 1.032200000 7.881194e-05 1.032800000 9.369906e-05 1.033400000 1.107635e-04 1.034000000 1.302130e-04 1.035100000 1.727683e-04 1.036200000 2.253649e-04 1.037200000 2.829795e-04 1.038200000 3.508784e-04 1.039200000 4.299035e-04 1.040200000 5.207912e-04 1.042100000 7.282096e-04 1.044000000 9.831117e-04 1.045900000 1.285823e-03 1.049000000 1.876293e-03 1.052300000 2.615305e-03 1.064400000 5.699938e-03 1.069900000 6.990682e-03 1.075700000 8.151984e-03 1.081600000 9.107068e-03 1.093200000 1.040337e-02 1.106900000 1.123670e-02 1.125000000 1.172460e-02 1.151500000 1.194815e-02 1.315300000 1.201597e-02 1.408100000 1.201452e-02 1.484300000 8.641671e-03 1.576600000 4.965679e-03 1.587000000 4.328358e-03 1.608700000 2.414156e-03 1.615000000 1.930337e-03 1.621200000 1.523629e-03 1.628400000 1.137953e-03 1.632100000 9.736160e-04 1.636000000 8.229856e-04 1.640000000 6.903614e-04 1.644100000 5.749057e-04 1.648500000 4.711742e-04 1.653100000 3.818700e-04 1.658200000 3.019903e-04 1.663700000 2.342155e-04 1.668600000 1.867185e-04 1.678500000 1.065439e-04 1.681200000 8.788460e-05 1.683700000 7.303931e-05 1.686100000 6.130088e-05 1.688700000 5.117534e-05 1.690700000 4.487022e-05 1.692600000 3.994781e-05 1.696700000 3.386638e-05 1.701300000 2.826786e-05 1.706800000 2.286791e-05 1.712700000 1.829627e-05 1.719300000 1.432724e-05 1.726500000 1.103528e-05 1.730400000 9.603217e-06 1.734500000 8.312493e-06 1.738800000 7.158644e-06 1.743400000 6.114244e-06 1.748300000 5.181315e-06 1.753600000 4.343775e-06 1.759200000 3.616502e-06 1.765300000 2.972518e-06 1.771000000 2.482812e-06 1.777200000 2.048339e-06 1.783900000 1.670432e-06 1.791200000 1.343630e-06 1.799200000 1.063958e-06 1.807900000 8.303778e-07 1.817600000 6.342603e-07 1.822800000 5.505433e-07 1.828400000 4.737206e-07 1.833900000 4.095728e-07 1.839800000 3.511662e-07 1.846100000 2.986949e-07 1.852800000 2.521353e-07 1.860000000 2.107705e-07 1.867700000 1.745640e-07 1.876000000 1.429621e-07 1.885100000 1.152935e-07 1.894700000 9.226404e-08 1.905200000 7.263175e-08 1.916800000 5.604177e-08 1.929700000 4.224197e-08 1.944000000 3.107682e-08 1.951800000 2.635554e-08 1.960100000 2.215965e-08 1.969000000 1.843911e-08 1.978500000 1.519024e-08 1.988800000 1.234447e-08 2.000000000 9.882646e-09 ]
tran 1e-05 2.000000000002 0 1e-05
wrdata perdita_l41c$d v(mainjack) v(fixjack1) v(fixjack2)
wrdata perdita_l41c_stati$d v(xls.xs) v(xlp.xs) v(dep) v(ina) v(vplus) v(vminus) v(main_a) v(mainc) v(fixc1) v(fixc2)
destroy all
echo "perdita_l41c,perdita_l41c.dat,l41c_perdita,1000,0,10a0,100k,0.990000000,1000,2.000000000002,1e-05,evento,rif_perdita_l41c,-,0.0,6,A_ins" >> tb_v2_casopeggiore_manifest.csv
* ---- L41c: rif_perdita_min_l41c (dal ponte: perdita_min, giro 3) ----
alter vamp dc = 0
alter vfrq dc = 1000
alter rldm = 100k
alter rld1 = 100k
alter rld2 = 100k
alter vti dc = 1000
alter vtr dc = 2000
alter vtijk dc = 1000
alter vtrjk dc = 1000
alter vosa dc = 0
alter vosb dc = 0
alter vosf1 dc = 0
alter vosf2 dc = 0
alter ratth = 1m
alter rattb = 10k
alter rl1 = 845
alter cwire = 100p
alter vk1bi dc = 1
alter vk1bt dc = 1000.000000
alter vk5bi dc = 1
alter vk5bt dc = 1000.000000
alter vk1i dc = 0
alter vk1t dc = 1000.000000
alter vk5i dc = 0
alter vk5t dc = 1000.000000
alter vt1ri dc = 1
alter vt1rt dc = 1000.000000
alter vt1si dc = 0
alter vt1st dc = 1000.000000
alter vt2ri dc = 1
alter vt2rt dc = 1000.000000
alter vt2si dc = 0
alter vt2st dc = 1000.000000
alter vtijk dc = 1000.000000
alter vtrjk dc = 2000.000000
alter vksa dc = 1000.000000
alter vksb dc = 1000.001000
alter vkca dc = 1000.001000
alter vkcb dc = 1000.000000
alter vtiser dc = -10
alter vtrser dc = 1000
alter rbym = 1e12
alter rby1 = 1e12
alter rby2 = 1e12
alter rbcm = 220k
alter rbc1 = 470k
alter rbc2 = 470k
alter cksm = 0.1p
alter cks1 = 0.1p
alter cks2 = 0.1p
alter ccavm = 1e-18
alter ccav1 = 1e-18
alter ccav2 = 1e-18
print @cksm[capacitance] @cks1[capacitance] @cks2[capacitance] @ccavm[capacitance] @ccav1[capacitance] @ccav2[capacitance]
alter @vpp[pwl] = [ 0.000100000 14.999735 0.990000000 14.999735 2.000000000 14.999735 ]
alter @vmm[pwl] = [ 0.000100000 -15.052534 0.990000000 -15.052534 2.000000000 -15.052534 ]
alter @vpwl[pwl] = [ 0 1 1000 1 ]
alter @vis[pwl] = [ 0.000100000 1.167331e-02 0.990000000 1.167331e-02 2.000000000 1.167331e-02 ]
alter @vip[pwl] = [ 0.000100000 1.188839e-08 0.990000000 1.188839e-08 2.000000000 1.188839e-08 ]
tran 1e-05 2.000000000002 0 1e-05
wrdata rif_perdita_min_l41c$d v(mainjack) v(fixjack1) v(fixjack2)
wrdata rif_perdita_min_l41c_stati$d v(xls.xs) v(xlp.xs) v(dep) v(ina) v(vplus) v(vminus) v(main_a) v(mainc) v(fixc1) v(fixc2)
destroy all
echo "rif_perdita_min_l41c,rif_perdita_min_l41c.dat,rif,1000,0,10,100k,0.990000000,1000,2.000000000002,1e-05,rif_mai,-,-,0.0,0," >> tb_v2_casopeggiore_manifest.csv
* ---- L41c: perdita_min_l41c (dal ponte: perdita_min, giro 3) ----
alter vamp dc = 0
alter vfrq dc = 1000
alter rldm = 100k
alter rld1 = 100k
alter rld2 = 100k
alter vti dc = 1000
alter vtr dc = 2000
alter vtijk dc = 1.0174000000000003
alter vtrjk dc = 1000
alter vosa dc = 0
alter vosb dc = 0
alter vosf1 dc = 0
alter vosf2 dc = 0
alter ratth = 1m
alter rattb = 10k
alter rl1 = 845
alter cwire = 100p
alter vk1bi dc = 1
alter vk1bt dc = 1.033400
alter vk5bi dc = 1
alter vk5bt dc = 1.033700
alter vk1i dc = 0
alter vk1t dc = 1000.000000
alter vk5i dc = 0
alter vk5t dc = 1000.000000
alter vt1ri dc = 1
alter vt1rt dc = 1000.000000
alter vt1si dc = 0
alter vt1st dc = 1000.000000
alter vt2ri dc = 1
alter vt2rt dc = 1000.000000
alter vt2si dc = 0
alter vt2st dc = 1000.000000
alter vtijk dc = 1000.000000
alter vtrjk dc = 2000.000000
alter vksa dc = 1.017400
alter vksb dc = 1000.001000
alter vkca dc = 1.018400
alter vkcb dc = 1000.000000
alter vtiser dc = -10
alter vtrser dc = 1000
alter rbym = 1e12
alter rby1 = 1e12
alter rby2 = 1e12
alter rbcm = 220k
alter rbc1 = 470k
alter rbc2 = 470k
alter cksm = 0.1p
alter cks1 = 0.1p
alter cks2 = 0.1p
alter ccavm = 1e-18
alter ccav1 = 1e-18
alter ccav2 = 1e-18
print @cksm[capacitance] @cks1[capacitance] @cks2[capacitance] @ccavm[capacitance] @ccav1[capacitance] @ccav2[capacitance]
alter @vpp[pwl] = [ 0.000100000 14.999735 1.074400000 14.999735 1.074500000 14.997386 1.074600000 14.992914 1.079900000 14.740998 1.082500000 14.618915 1.085100000 14.497841 1.089400000 14.299795 1.093800000 14.099937 1.098500000 13.889530 1.103200000 13.682255 1.107900000 13.478067 1.112600000 13.276918 1.117400000 13.074580 1.122200000 12.875318 1.127100000 12.675029 1.132000000 12.477848 1.136900000 12.283726 1.141800000 12.092617 1.146800000 11.900664 1.151800000 11.711749 1.156800000 11.525825 1.161900000 11.339215 1.167000000 11.155617 1.172100000 10.974983 1.177200000 10.797266 1.182400000 10.619018 1.187600000 10.443703 1.192900000 10.267986 1.198200000 10.095216 1.203500000 9.925344 1.208800000 9.758322 1.214200000 9.591028 1.219600000 9.426593 1.225000000 9.264968 1.230400000 9.106104 1.235900000 8.947089 1.241400000 8.790840 1.246900000 8.637310 1.252500000 8.483732 1.258100000 8.332875 1.263700000 8.184691 1.269400000 8.036555 1.275100000 7.891090 1.280900000 7.745765 1.286700000 7.603104 1.292500000 7.463060 1.298400000 7.323237 1.304300000 7.186021 1.310200000 7.051365 1.316200000 6.917003 1.322200000 6.785189 1.328200000 6.655875 1.334300000 6.526920 1.340400000 6.400451 1.346600000 6.274407 1.352800000 6.150833 1.359000000 6.029680 1.365300000 5.909004 1.371600000 5.790730 1.378000000 5.672989 1.384400000 5.557628 1.390900000 5.442852 1.397400000 5.330433 1.403900000 5.220321 1.410500000 5.110829 1.417200000 5.002011 1.423900000 4.895496 1.430600000 4.791234 1.437300000 4.689178 1.444100000 4.587806 1.450900000 4.488610 1.457700000 4.391544 1.464600000 4.295180 1.471600000 4.199564 1.478600000 4.106061 1.485700000 4.013331 1.492800000 3.922680 1.500000000 3.832825 1.507200000 3.745012 1.514500000 3.658015 1.521800000 3.573022 1.529200000 3.488861 1.536700000 3.405568 1.544200000 3.324245 1.551800000 3.243799 1.559400000 3.165281 1.567100000 3.087648 1.574800000 3.011900 1.582600000 2.937043 1.590500000 2.863102 1.598500000 2.790101 1.606500000 2.718940 1.614600000 2.648717 1.622800000 2.579452 1.631000000 2.511976 1.639300000 2.445452 1.647700000 2.379898 1.656100000 2.316077 1.664700000 2.252485 1.673300000 2.190615 1.682000000 2.129730 1.690700000 2.070511 1.699600000 2.011610 1.708500000 1.954357 1.717500000 1.898092 1.726600000 1.842821 1.735800000 1.788551 1.745000000 1.735851 1.754400000 1.683580 1.763800000 1.632854 1.773400000 1.582596 1.783000000 1.533854 1.792700000 1.486098 1.802600000 1.438858 1.812500000 1.393087 1.822600000 1.347859 1.832700000 1.304065 1.843000000 1.260834 1.853400000 1.218601 1.863900000 1.177362 1.874500000 1.137107 1.885300000 1.097470 1.896100000 1.059177 1.907100000 1.021507 1.918200000 0.984812 1.929500000 0.948767 1.940900000 0.913697 1.952400000 0.879589 1.964100000 0.846149 1.975900000 0.813664 1.987900000 0.781860 2.000000000 0.751000 ]
alter @vmm[pwl] = [ 0.000100000 -15.052534 1.073200000 -15.052534 1.073300000 -15.050821 1.073400000 -15.046404 1.076300000 -14.907409 1.078900000 -14.783765 1.081500000 -14.661143 1.084200000 -14.534877 1.088500000 -14.336020 1.092800000 -14.139872 1.097400000 -13.932997 1.102100000 -13.724739 1.106800000 -13.519580 1.111500000 -13.317476 1.116300000 -13.114176 1.121100000 -12.913966 1.126000000 -12.712724 1.130900000 -12.514603 1.135800000 -12.319557 1.140800000 -12.123649 1.145800000 -11.930841 1.150800000 -11.741086 1.155800000 -11.554334 1.160900000 -11.366892 1.166000000 -11.182475 1.171100000 -11.001036 1.176200000 -10.822525 1.181400000 -10.643480 1.186600000 -10.467382 1.191900000 -10.290879 1.197200000 -10.117336 1.202500000 -9.946703 1.207800000 -9.778932 1.213200000 -9.610889 1.218600000 -9.445716 1.224000000 -9.283365 1.229400000 -9.123788 1.234900000 -8.964057 1.240400000 -8.807106 1.246000000 -8.650105 1.251600000 -8.495886 1.257200000 -8.344397 1.262800000 -8.195592 1.268500000 -8.046836 1.274200000 -7.900760 1.280000000 -7.754825 1.285800000 -7.611565 1.291600000 -7.470932 1.297500000 -7.330520 1.303400000 -7.192727 1.309300000 -7.057504 1.315300000 -6.922575 1.321300000 -6.790205 1.327300000 -6.660345 1.333400000 -6.530846 1.339500000 -6.403842 1.345700000 -6.277265 1.351900000 -6.153167 1.358200000 -6.029558 1.364500000 -5.908408 1.370800000 -5.789670 1.377200000 -5.671467 1.383600000 -5.555653 1.390100000 -5.440425 1.396600000 -5.327563 1.403100000 -5.217018 1.409700000 -5.107094 1.416400000 -4.997847 1.423100000 -4.890910 1.429800000 -4.786236 1.436500000 -4.683776 1.443300000 -4.582003 1.450100000 -4.482414 1.456900000 -4.384962 1.463800000 -4.288216 1.470800000 -4.192220 1.477800000 -4.098344 1.484900000 -4.005245 1.492000000 -3.914232 1.499200000 -3.824019 1.506400000 -3.735855 1.513700000 -3.648511 1.521100000 -3.562022 1.528500000 -3.477552 1.536000000 -3.393951 1.543500000 -3.312327 1.551100000 -3.231584 1.558700000 -3.152776 1.566400000 -3.074856 1.574200000 -2.997852 1.582000000 -2.922740 1.589900000 -2.848548 1.597900000 -2.775299 1.605900000 -2.703895 1.614000000 -2.633433 1.622200000 -2.563932 1.630500000 -2.495411 1.638800000 -2.428681 1.647200000 -2.362922 1.655600000 -2.298903 1.664200000 -2.235113 1.672800000 -2.173050 1.681500000 -2.111975 1.690200000 -2.052572 1.699100000 -1.993487 1.708000000 -1.936056 1.717000000 -1.879616 1.726100000 -1.824174 1.735300000 -1.769735 1.744600000 -1.716306 1.754000000 -1.663889 1.763400000 -1.613022 1.773000000 -1.562625 1.782600000 -1.513748 1.792300000 -1.465860 1.802200000 -1.418489 1.812200000 -1.372136 1.822300000 -1.326797 1.832500000 -1.282469 1.842800000 -1.239146 1.853200000 -1.196825 1.863700000 -1.155498 1.874300000 -1.115159 1.885100000 -1.075439 1.896000000 -1.036716 1.907000000 -0.998979 1.918100000 -0.962219 1.929400000 -0.926111 1.940800000 -0.890979 1.952400000 -0.856520 1.964100000 -0.823031 1.975900000 -0.790500 1.987900000 -0.758651 2.000000000 -0.727747 ]
alter @vpwl[pwl] = [ 0 1 1000 1 ]
alter @vis[pwl] = [ 0.000100000 1.167331e-02 1.014300000 1.167331e-02 1.014400000 1.130653e-02 1.014700000 9.374593e-03 1.015000000 7.746247e-03 1.015300000 6.384251e-03 1.015700000 4.920366e-03 1.016000000 4.043223e-03 1.016400000 3.111647e-03 1.016800000 2.397241e-03 1.017000000 2.105657e-03 1.017300000 1.735506e-03 1.017500000 1.527062e-03 1.017800000 1.262374e-03 1.018100000 1.045725e-03 1.018400000 8.681849e-04 1.018700000 7.224755e-04 1.019000000 6.026821e-04 1.019400000 4.751110e-04 1.019800000 3.762417e-04 1.020200000 2.993134e-04 1.020400000 2.674261e-04 1.020700000 2.263366e-04 1.021200000 1.723805e-04 1.021500000 1.468949e-04 1.021800000 1.254941e-04 1.022100000 1.074801e-04 1.022500000 8.775510e-05 1.022800000 7.559071e-05 1.023200000 6.218535e-05 1.023600000 5.137298e-05 1.024000000 4.261617e-05 1.024500000 3.393072e-05 1.025000000 2.718263e-05 1.025400000 2.286305e-05 1.025900000 1.851337e-05 1.026400000 1.507744e-05 1.026900000 1.234797e-05 1.027500000 9.786512e-06 1.028100000 7.815413e-06 1.028500000 6.754778e-06 1.028900000 5.856739e-06 1.029300000 5.093970e-06 1.029700000 4.444097e-06 1.030100000 3.888738e-06 1.030600000 3.304631e-06 1.031100000 2.820777e-06 1.031600000 2.418210e-06 1.032200000 2.021410e-06 1.032800000 1.699671e-06 1.033400000 1.437286e-06 1.034100000 1.190144e-06 1.034900000 9.677815e-07 1.035700000 7.940955e-07 1.036600000 6.422552e-07 1.037700000 5.025568e-07 1.038800000 3.990581e-07 1.039400000 3.539683e-07 1.040100000 3.093127e-07 1.040800000 2.717069e-07 1.041600000 2.357399e-07 1.042400000 2.058264e-07 1.043300000 1.779630e-07 1.044300000 1.527004e-07 1.045400000 1.303061e-07 1.046600000 1.108227e-07 1.048000000 9.300200e-08 1.049500000 7.825032e-08 1.051100000 6.612662e-08 1.053000000 5.520625e-08 1.055100000 4.623152e-08 1.057400000 3.897648e-08 1.060000000 3.298232e-08 1.063000000 2.801331e-08 1.066500000 2.393753e-08 1.070500000 2.072593e-08 1.075200000 1.817779e-08 1.080800000 1.618893e-08 1.087600000 1.467019e-08 1.096000000 1.355529e-08 1.106400000 1.279434e-08 1.137700000 1.204317e-08 1.410500000 1.188715e-08 1.472100000 8.724427e-09 1.541000000 5.892156e-09 1.613700000 3.544054e-09 1.673800000 2.072769e-09 1.675500000 2.180937e-09 1.681200000 3.704741e-09 1.686000000 5.944934e-09 1.688200000 7.419140e-09 1.690400000 9.254889e-09 1.695000000 1.422550e-08 1.712200000 2.352292e-08 1.731400000 3.549670e-08 1.750800000 4.931294e-08 1.768500000 6.392646e-08 1.786200000 8.098545e-08 1.802900000 9.976900e-08 1.842800000 1.539185e-07 1.853700000 1.608264e-07 1.859900000 1.582326e-07 1.866600000 1.503477e-07 1.903300000 8.240466e-08 1.915800000 6.400778e-08 1.928700000 4.899253e-08 1.943600000 3.588367e-08 1.951600000 3.036512e-08 1.960000000 2.549961e-08 1.969000000 2.117236e-08 1.978600000 1.739039e-08 1.988900000 1.410968e-08 2.000000000 1.129309e-08 ]
alter @vip[pwl] = [ 0.000100000 1.188839e-08 1.014300000 1.188839e-08 1.014400000 1.231767e-08 1.014700000 1.501957e-08 1.015200000 2.103869e-08 1.015600000 2.762316e-08 1.016000000 3.627043e-08 1.016300000 4.444889e-08 1.016500000 5.086473e-08 1.016800000 6.217939e-08 1.017000000 7.101275e-08 1.017400000 9.235456e-08 1.017800000 1.196039e-07 1.018200000 1.541930e-07 1.018500000 1.859778e-07 1.018900000 2.377708e-07 1.019200000 2.849659e-07 1.019500000 3.405899e-07 1.019800000 4.059534e-07 1.020300000 5.406416e-07 1.020800000 7.146222e-07 1.021300000 9.376268e-07 1.021800000 1.221328e-06 1.022200000 1.501241e-06 1.022600000 1.837095e-06 1.023000000 2.238272e-06 1.023400000 2.715386e-06 1.023700000 3.130191e-06 1.024100000 3.769817e-06 1.024400000 4.322404e-06 1.024800000 5.169151e-06 1.025100000 5.896233e-06 1.025700000 7.622265e-06 1.026300000 9.771398e-06 1.026800000 1.194417e-05 1.027300000 1.452029e-05 1.027800000 1.755810e-05 1.028300000 2.112152e-05 1.028800000 2.528005e-05 1.029600000 3.336127e-05 1.030300000 4.210605e-05 1.031000000 5.267259e-05 1.031700000 6.532893e-05 1.032300000 7.805669e-05 1.032900000 9.271842e-05 1.033500000 1.095099e-04 1.034100000 1.286322e-04 1.035200000 1.704237e-04 1.036300000 2.220052e-04 1.037300000 2.784390e-04 1.038300000 3.448742e-04 1.039300000 4.221178e-04 1.040300000 5.108737e-04 1.042200000 7.131758e-04 1.044100000 9.614463e-04 1.046000000 1.255943e-03 1.049100000 1.829707e-03 1.052400000 2.547066e-03 1.064500000 5.538937e-03 1.070000000 6.791182e-03 1.075800000 7.918346e-03 1.081700000 8.845775e-03 1.093300000 1.010520e-02 1.107000000 1.091525e-02 1.125100000 1.138967e-02 1.151600000 1.160708e-02 1.315200000 1.167304e-02 1.410500000 1.167232e-02 1.488400000 8.336116e-03 1.582100000 4.739809e-03 1.592600000 4.124261e-03 1.614300000 2.297474e-03 1.620500000 1.843111e-03 1.626600000 1.460507e-03 1.633800000 1.091299e-03 1.637500000 9.340013e-04 1.641300000 7.932611e-04 1.645200000 6.687535e-04 1.649300000 5.573048e-04 1.653600000 4.591879e-04 1.658200000 3.724923e-04 1.663200000 2.962295e-04 1.668600000 2.310610e-04 1.673200000 1.869424e-04 1.679900000 1.297732e-04 1.684000000 9.831918e-05 1.686600000 8.126031e-05 1.689000000 6.805225e-05 1.691500000 5.698225e-05 1.694300000 4.726952e-05 1.696000000 4.365241e-05 1.699800000 3.742291e-05 1.703300000 3.255884e-05 1.707100000 2.805826e-05 1.712600000 2.270913e-05 1.718500000 1.817936e-05 1.725000000 1.429695e-05 1.732200000 1.101858e-05 1.736000000 9.625702e-06 1.740100000 8.334318e-06 1.744400000 7.179519e-06 1.749000000 6.133917e-06 1.753900000 5.199596e-06 1.759100000 4.374896e-06 1.764700000 3.643401e-06 1.770700000 3.005012e-06 1.776400000 2.510441e-06 1.782600000 2.071543e-06 1.789200000 1.694787e-06 1.796400000 1.367431e-06 1.804200000 1.089138e-06 1.812800000 8.523515e-07 1.822300000 6.545062e-07 1.827500000 5.680161e-07 1.833000000 4.899676e-07 1.838500000 4.235250e-07 1.844300000 3.639853e-07 1.850400000 3.110943e-07 1.857000000 2.631628e-07 1.864000000 2.209834e-07 1.871600000 1.833700e-07 1.879800000 1.504436e-07 1.888600000 1.221038e-07 1.898000000 9.808782e-08 1.908300000 7.749647e-08 1.919600000 6.013331e-08 1.932100000 4.566759e-08 1.946000000 3.383659e-08 1.953600000 2.879342e-08 1.961600000 2.433944e-08 1.970200000 2.035795e-08 1.979400000 1.685465e-08 1.989300000 1.378983e-08 2.000000000 1.113284e-08 ]
tran 1e-05 2.000000000002 0 1e-05
wrdata perdita_min_l41c$d v(mainjack) v(fixjack1) v(fixjack2)
wrdata perdita_min_l41c_stati$d v(xls.xs) v(xlp.xs) v(dep) v(ina) v(vplus) v(vminus) v(main_a) v(mainc) v(fixc1) v(fixc2)
destroy all
echo "perdita_min_l41c,perdita_min_l41c.dat,l41c_perdita_min,1000,0,10a0,100k,0.990000000,1000,2.000000000002,1e-05,evento,rif_perdita_min_l41c,-,0.0,6,A_ins" >> tb_v2_casopeggiore_manifest.csv
* ---- L41c: rif_guasto_l41c (dal ponte: guasto, giro 2) ----
alter vamp dc = 0
alter vfrq dc = 1000
alter rldm = 100k
alter rld1 = 100k
alter rld2 = 100k
alter vti dc = 1000
alter vtr dc = 2000
alter vtijk dc = 1000
alter vtrjk dc = 1000
alter vosa dc = 0
alter vosb dc = 0
alter vosf1 dc = 0
alter vosf2 dc = 0
alter ratth = 1m
alter rattb = 10k
alter rl1 = 845
alter cwire = 100p
alter vk1bi dc = 1
alter vk1bt dc = 1000.000000
alter vk5bi dc = 1
alter vk5bt dc = 1000.000000
alter vk1i dc = 0
alter vk1t dc = 1000.000000
alter vk5i dc = 0
alter vk5t dc = 1000.000000
alter vt1ri dc = 1
alter vt1rt dc = 1000.000000
alter vt1si dc = 0
alter vt1st dc = 1000.000000
alter vt2ri dc = 1
alter vt2rt dc = 1000.000000
alter vt2si dc = 0
alter vt2st dc = 1000.000000
alter vtijk dc = 1000.000000
alter vtrjk dc = 2000.000000
alter vksa dc = 1000.000000
alter vksb dc = 1000.001000
alter vkca dc = 1000.001000
alter vkcb dc = 1000.000000
alter vtiser dc = -10
alter vtrser dc = 1000
alter rbym = 1e12
alter rby1 = 1e12
alter rby2 = 1e12
alter rbcm = 220k
alter rbc1 = 470k
alter rbc2 = 470k
alter cksm = 0.1p
alter cks1 = 0.1p
alter cks2 = 0.1p
alter ccavm = 1e-18
alter ccav1 = 1e-18
alter ccav2 = 1e-18
print @cksm[capacitance] @cks1[capacitance] @cks2[capacitance] @ccavm[capacitance] @ccav1[capacitance] @ccav2[capacitance]
alter @vpp[pwl] = [ 0.000100000 14.999735 0.990000000 14.999735 2.000000000 14.999735 ]
alter @vmm[pwl] = [ 0.000100000 -15.052534 0.990000000 -15.052534 2.000000000 -15.052534 ]
alter @vpwl[pwl] = [ 0 1 1000 1 ]
alter @vis[pwl] = [ 0.000100000 1.201624e-02 0.990000000 1.201607e-02 2.000000000 1.201607e-02 ]
alter @vip[pwl] = [ 0.000100000 1.226115e-08 0.990000000 1.226097e-08 2.000000000 1.226097e-08 ]
tran 1e-05 2.000000000002 0 1e-05
wrdata rif_guasto_l41c$d v(mainjack) v(fixjack1) v(fixjack2)
wrdata rif_guasto_l41c_stati$d v(xls.xs) v(xlp.xs) v(dep) v(ina) v(vplus) v(vminus) v(main_a) v(mainc) v(fixc1) v(fixc2)
destroy all
echo "rif_guasto_l41c,rif_guasto_l41c.dat,rif,1000,0,10,100k,0.990000000,1000,2.000000000002,1e-05,rif_mai,-,-,0.0,0," >> tb_v2_casopeggiore_manifest.csv
* ---- L41c: guasto_l41c (dal ponte: guasto, giro 2) ----
alter vamp dc = 0
alter vfrq dc = 1000
alter rldm = 100k
alter rld1 = 100k
alter rld2 = 100k
alter vti dc = 1000
alter vtr dc = 2000
alter vtijk dc = 1.0137
alter vtrjk dc = 1000
alter vosa dc = 0
alter vosb dc = 0
alter vosf1 dc = 0
alter vosf2 dc = 0
alter ratth = 1m
alter rattb = 10k
alter rl1 = 845
alter cwire = 100p
alter vk1bi dc = 1
alter vk1bt dc = 1.031000
alter vk5bi dc = 1
alter vk5bt dc = 1.031300
alter vk1i dc = 0
alter vk1t dc = 1000.000000
alter vk5i dc = 0
alter vk5t dc = 1000.000000
alter vt1ri dc = 1
alter vt1rt dc = 1000.000000
alter vt1si dc = 0
alter vt1st dc = 1000.000000
alter vt2ri dc = 1
alter vt2rt dc = 1000.000000
alter vt2si dc = 0
alter vt2st dc = 1000.000000
alter vtijk dc = 1000.000000
alter vtrjk dc = 2000.000000
alter vksa dc = 1.013700
alter vksb dc = 1000.001000
alter vkca dc = 1.014700
alter vkcb dc = 1000.000000
alter vtiser dc = -10
alter vtrser dc = 1000
alter rbym = 1e12
alter rby1 = 1e12
alter rby2 = 1e12
alter rbcm = 220k
alter rbc1 = 470k
alter rbc2 = 470k
alter cksm = 0.1p
alter cks1 = 0.1p
alter cks2 = 0.1p
alter ccavm = 1e-18
alter ccav1 = 1e-18
alter ccav2 = 1e-18
print @cksm[capacitance] @cks1[capacitance] @cks2[capacitance] @ccavm[capacitance] @ccav1[capacitance] @ccav2[capacitance]
alter @vpp[pwl] = [ 0.000100000 14.999735 1.184400000 14.999735 1.184500000 14.997428 1.184600000 14.992960 1.189600000 14.755197 1.194500000 14.525739 1.198500000 14.341068 1.202500000 14.158740 1.206800000 13.965316 1.211100000 13.774528 1.215400000 13.586340 1.219700000 13.400717 1.224100000 13.213397 1.228600000 13.024520 1.233000000 12.842445 1.237500000 12.658858 1.242000000 12.477888 1.246600000 12.295564 1.251100000 12.119775 1.255700000 11.942669 1.260300000 11.768145 1.265000000 11.592453 1.269700000 11.419378 1.274400000 11.248878 1.279100000 11.080918 1.283900000 10.911964 1.288600000 10.749019 1.293400000 10.585111 1.298200000 10.423695 1.303000000 10.264732 1.307900000 10.104951 1.312800000 9.947648 1.317700000 9.792786 1.322600000 9.640328 1.327600000 9.487196 1.332600000 9.336488 1.337600000 9.188166 1.342700000 9.039296 1.347800000 8.892830 1.352900000 8.748728 1.358000000 8.606953 1.363200000 8.464755 1.368400000 8.324897 1.373600000 8.187340 1.378800000 8.052048 1.384100000 7.916445 1.389400000 7.783116 1.394800000 7.649572 1.400100000 7.520719 1.405500000 7.391658 1.410900000 7.264802 1.416400000 7.137825 1.421900000 7.013057 1.427400000 6.890460 1.432900000 6.769996 1.438500000 6.649496 1.444100000 6.531129 1.449800000 6.412802 1.455500000 6.296609 1.461200000 6.182509 1.467000000 6.068519 1.472800000 5.956620 1.478600000 5.846773 1.484500000 5.737099 1.490400000 5.629470 1.496300000 5.523849 1.502300000 5.418459 1.508300000 5.315067 1.514300000 5.213636 1.520400000 5.112487 1.526500000 5.013288 1.532600000 4.916001 1.538800000 4.819042 1.545000000 4.723982 1.551200000 4.630784 1.557500000 4.537954 1.563800000 4.446971 1.570200000 4.356398 1.576600000 4.267657 1.583100000 4.179365 1.589600000 4.092886 1.596200000 4.006893 1.602800000 3.922692 1.609400000 3.840247 1.616100000 3.758309 1.622800000 3.678106 1.629600000 3.598440 1.636400000 3.520484 1.643300000 3.443092 1.650200000 3.367386 1.657200000 3.292267 1.664300000 3.217771 1.671400000 3.144943 1.678500000 3.073747 1.685700000 3.003177 1.693000000 2.933264 1.700300000 2.864960 1.707700000 2.797326 1.715100000 2.731271 1.722600000 2.665896 1.730100000 2.602067 1.737700000 2.538927 1.745400000 2.476499 1.753100000 2.415587 1.760900000 2.355391 1.768800000 2.295931 1.776700000 2.237952 1.784700000 2.180710 1.792800000 2.124222 1.800900000 2.069176 1.809100000 2.014881 1.817300000 1.961989 1.825600000 1.909842 1.834000000 1.858455 1.842500000 1.807840 1.851100000 1.758008 1.859800000 1.708969 1.868500000 1.661273 1.877300000 1.614357 1.886200000 1.568230 1.895200000 1.522898 1.904200000 1.478849 1.913400000 1.435110 1.922600000 1.392637 1.932000000 1.350509 1.941400000 1.309627 1.950900000 1.269537 1.960500000 1.230241 1.970200000 1.191740 1.980000000 1.154034 1.989900000 1.117122 2.000000000 1.080647 ]
alter @vmm[pwl] = [ 0.000100000 -15.052534 1.000000000 -15.052534 1.000100000 -15.029735 1.001000000 -14.895262 1.001800000 -14.776741 1.002700000 -14.644532 1.003500000 -14.528006 1.004400000 -14.398022 1.005700000 -14.212317 1.007100000 -14.015006 1.008500000 -13.820433 1.009900000 -13.628561 1.011200000 -13.452780 1.012600000 -13.266013 1.013900000 -13.094908 1.015300000 -12.913108 1.016600000 -12.746554 1.018000000 -12.569590 1.019300000 -12.407467 1.020700000 -12.235210 1.022000000 -12.077400 1.023400000 -11.909725 1.024800000 -11.744378 1.026200000 -11.581326 1.027600000 -11.420538 1.029000000 -11.261982 1.030400000 -11.105627 1.031800000 -10.951443 1.033200000 -10.799399 1.034600000 -10.649466 1.036000000 -10.501614 1.037500000 -10.345478 1.038900000 -10.201846 1.040400000 -10.050167 1.041800000 -9.910634 1.043300000 -9.763284 1.044700000 -9.627734 1.046200000 -9.484590 1.047700000 -9.343573 1.049200000 -9.204653 1.050700000 -9.067798 1.052200000 -8.932978 1.053700000 -8.800162 1.055200000 -8.669320 1.056700000 -8.540424 1.058200000 -8.413444 1.059700000 -8.288351 1.061300000 -8.156968 1.062800000 -8.035688 1.064400000 -7.908310 1.066000000 -7.782951 1.067600000 -7.659578 1.069200000 -7.538161 1.070800000 -7.418668 1.072400000 -7.301069 1.074000000 -7.185334 1.075600000 -7.071433 1.077200000 -6.959338 1.078800000 -6.849019 1.080500000 -6.733721 1.082100000 -6.626978 1.083800000 -6.515417 1.085500000 -6.405733 1.087200000 -6.297896 1.088900000 -6.191874 1.090600000 -6.087636 1.092300000 -5.985153 1.094000000 -5.884395 1.095700000 -5.785333 1.097500000 -5.682260 1.099200000 -5.586600 1.101000000 -5.487068 1.102700000 -5.394693 1.104500000 -5.298579 1.106300000 -5.204177 1.108100000 -5.111456 1.109900000 -5.020387 1.111700000 -4.930941 1.113500000 -4.843087 1.115400000 -4.752050 1.117200000 -4.667384 1.119100000 -4.579649 1.120900000 -4.498053 1.122800000 -4.413500 1.124700000 -4.330536 1.126600000 -4.249132 1.128500000 -4.169257 1.130500000 -4.086800 1.132400000 -4.009976 1.134400000 -3.930668 1.136300000 -3.856778 1.138300000 -3.780499 1.140300000 -3.705729 1.142300000 -3.632436 1.144300000 -3.560593 1.146300000 -3.490170 1.148300000 -3.421140 1.150400000 -3.350127 1.152500000 -3.280587 1.154600000 -3.212491 1.156700000 -3.145807 1.158800000 -3.080507 1.160900000 -3.016562 1.163100000 -2.950995 1.165200000 -2.889738 1.167400000 -2.826926 1.169600000 -2.765480 1.171800000 -2.705368 1.174000000 -2.646563 1.176300000 -2.586450 1.178500000 -2.530228 1.180800000 -2.472757 1.183100000 -2.416590 1.185400000 -2.361699 1.187700000 -2.308054 1.190100000 -2.253374 1.192500000 -2.199990 1.194900000 -2.147869 1.197300000 -2.096983 1.199700000 -2.047302 1.202100000 -1.998797 1.204600000 -1.949492 1.207100000 -1.901403 1.209600000 -1.854499 1.212100000 -1.808752 1.214700000 -1.762371 1.217200000 -1.718895 1.219800000 -1.674817 1.222400000 -1.631868 1.225100000 -1.588432 1.227700000 -1.547697 1.230400000 -1.506500 1.235100000 -1.437383 1.239800000 -1.371436 1.244600000 -1.307204 1.249500000 -1.244735 1.254500000 -1.184064 1.259600000 -1.125222 1.264800000 -1.068234 1.270000000 -1.014129 1.275400000 -0.960839 1.280800000 -0.910347 1.286300000 -0.861643 1.292000000 -0.813912 1.297700000 -0.768823 1.303600000 -0.724776 1.309600000 -0.682567 1.315700000 -0.642170 1.321900000 -0.603556 1.328300000 -0.566126 1.334800000 -0.530483 1.341400000 -0.496582 1.348200000 -0.463913 1.355100000 -0.432956 1.362200000 -0.403252 1.369400000 -0.375204 1.376900000 -0.348055 1.384500000 -0.322542 1.392300000 -0.298294 1.400300000 -0.275311 1.408500000 -0.253584 1.417000000 -0.232863 1.425700000 -0.213399 1.434700000 -0.194966 1.443100000 -0.179195 1.451700000 -0.164362 1.460600000 -0.150295 1.469700000 -0.137148 1.479100000 -0.124766 1.488800000 -0.113150 1.498900000 -0.102194 1.509300000 -0.092009 1.531200000 -0.073728 1.554800000 -0.058026 1.580400000 -0.044698 1.608400000 -0.033537 1.637500000 -0.024813 1.669800000 -0.017679 1.705900000 -0.012007 1.747000000 -0.007608 1.793400000 -0.004393 1.848200000 -0.002094 2.000000000 0.000368 ]
alter @vpwl[pwl] = [ 0 1 1000 1 ]
alter @vis[pwl] = [ 0.000100000 1.201624e-02 1.010600000 1.201607e-02 1.010700000 1.173458e-02 1.011000000 9.741615e-03 1.011400000 7.560118e-03 1.011700000 6.232490e-03 1.012000000 5.129516e-03 1.012400000 3.951205e-03 1.012800000 3.043266e-03 1.013200000 2.346680e-03 1.013400000 2.062246e-03 1.013700000 1.700998e-03 1.013900000 1.497476e-03 1.014200000 1.238907e-03 1.014500000 1.027117e-03 1.014800000 8.534332e-04 1.015100000 7.107833e-04 1.015400000 5.934163e-04 1.015800000 4.683178e-04 1.016200000 3.712627e-04 1.016600000 2.956730e-04 1.016800000 2.643135e-04 1.017100000 2.238782e-04 1.017600000 1.707284e-04 1.018100000 1.311179e-04 1.018400000 1.122865e-04 1.018800000 9.166826e-05 1.019100000 7.895411e-05 1.019500000 6.494418e-05 1.019900000 5.364491e-05 1.020300000 4.449550e-05 1.020800000 3.542154e-05 1.021300000 2.837261e-05 1.021700000 2.386105e-05 1.022200000 1.931863e-05 1.022700000 1.573098e-05 1.023200000 1.288136e-05 1.023800000 1.020760e-05 1.024400000 8.150356e-06 1.024800000 7.043522e-06 1.025200000 6.106461e-06 1.025600000 5.310628e-06 1.026000000 4.632634e-06 1.026400000 4.053333e-06 1.026900000 3.444089e-06 1.027400000 2.939472e-06 1.027900000 2.519676e-06 1.028500000 2.105943e-06 1.029100000 1.770515e-06 1.029700000 1.497002e-06 1.030400000 1.239407e-06 1.031200000 1.007678e-06 1.032000000 8.267002e-07 1.032900000 6.685081e-07 1.034000000 5.229884e-07 1.035100000 4.151970e-07 1.035700000 3.682427e-07 1.036400000 3.217455e-07 1.037100000 2.825923e-07 1.037900000 2.451487e-07 1.038700000 2.140103e-07 1.039600000 1.850089e-07 1.040600000 1.587173e-07 1.041700000 1.354134e-07 1.042900000 1.151410e-07 1.044300000 9.660090e-08 1.045800000 8.125561e-08 1.047400000 6.864566e-08 1.049200000 5.780810e-08 1.051300000 4.834049e-08 1.053600000 4.069572e-08 1.056200000 3.438656e-08 1.059200000 2.916214e-08 1.062600000 2.498358e-08 1.066600000 2.158161e-08 1.071200000 1.893407e-08 1.076700000 1.684812e-08 1.083400000 1.524246e-08 1.094700000 1.376226e-08 1.110000000 1.288026e-08 1.113600000 1.076965e-08 1.117900000 9.105142e-09 1.123000000 7.839178e-09 1.129300000 6.871727e-09 1.144300000 5.775457e-09 1.167600000 5.236355e-09 1.240700000 5.028873e-09 2.000000000 5.023835e-09 ]
alter @vip[pwl] = [ 0.000100000 1.226115e-08 1.010600000 1.226096e-08 1.010700000 1.259841e-08 1.011100000 1.644513e-08 1.011600000 2.308911e-08 1.011900000 2.834067e-08 1.012100000 3.248997e-08 1.012500000 4.266199e-08 1.012800000 5.225744e-08 1.013000000 5.977075e-08 1.013300000 7.299725e-08 1.013500000 8.330444e-08 1.013800000 1.013618e-07 1.014000000 1.153696e-07 1.014400000 1.489502e-07 1.014800000 1.914007e-07 1.015100000 2.302735e-07 1.015500000 2.933957e-07 1.015800000 3.507214e-07 1.016100000 4.180918e-07 1.016400000 4.970434e-07 1.016900000 6.591165e-07 1.017400000 8.675374e-07 1.017900000 1.133529e-06 1.018400000 1.470490e-06 1.018800000 1.801732e-06 1.019200000 2.197895e-06 1.019600000 2.669623e-06 1.020000000 3.228905e-06 1.020300000 3.713879e-06 1.020700000 4.459760e-06 1.021000000 5.102519e-06 1.021400000 6.084960e-06 1.021700000 6.926515e-06 1.022300000 8.918043e-06 1.022900000 1.138788e-05 1.023500000 1.442607e-05 1.024000000 1.746494e-05 1.024500000 2.103384e-05 1.025000000 2.520346e-05 1.025500000 3.005051e-05 1.026200000 3.813261e-05 1.026900000 4.795059e-05 1.027600000 5.977051e-05 1.028200000 7.171144e-05 1.028800000 8.552313e-05 1.029400000 1.014039e-04 1.030000000 1.195584e-04 1.030600000 1.401966e-04 1.031700000 1.851909e-04 1.032700000 2.350631e-04 1.033700000 2.944703e-04 1.034700000 3.643208e-04 1.035700000 4.454388e-04 1.036600000 5.286725e-04 1.038500000 7.380700e-04 1.040400000 9.950106e-04 1.042300000 1.299720e-03 1.045300000 1.872270e-03 1.048600000 2.610690e-03 1.060900000 5.744643e-03 1.066600000 7.073416e-03 1.072900000 8.308651e-03 1.079200000 9.285397e-03 1.085800000 1.006057e-02 1.092900000 1.066501e-02 1.110000000 1.147559e-02 1.110300000 9.547023e-03 1.110600000 7.895037e-03 1.110900000 6.509854e-03 1.111300000 5.017774e-03 1.111600000 4.121937e-03 1.112000000 3.169202e-03 1.112400000 2.437850e-03 1.112600000 2.139248e-03 1.112900000 1.760192e-03 1.113100000 1.546774e-03 1.113400000 1.275902e-03 1.113600000 1.123334e-03 1.113900000 9.294993e-04 1.114200000 7.707012e-04 1.114500000 6.404230e-04 1.114900000 5.020761e-04 1.115300000 3.952492e-04 1.115700000 3.124694e-04 1.115900000 2.782726e-04 1.116200000 2.343347e-04 1.116400000 2.092484e-04 1.116700000 1.769179e-04 1.116900000 1.584008e-04 1.117200000 1.344612e-04 1.117500000 1.144122e-04 1.117800000 9.758230e-05 1.118100000 8.342271e-05 1.118500000 6.793010e-05 1.118900000 5.553918e-05 1.119300000 4.558986e-05 1.119800000 3.581748e-05 1.120300000 2.830903e-05 1.120700000 2.355171e-05 1.121100000 1.966604e-05 1.121600000 1.577742e-05 1.122100000 1.272757e-05 1.122700000 9.905387e-06 1.123300000 7.767099e-06 1.123600000 6.896771e-06 1.124000000 5.902549e-06 1.124700000 4.528804e-06 1.125100000 3.908872e-06 1.125500000 3.383815e-06 1.125900000 2.937809e-06 1.126400000 2.471906e-06 1.126900000 2.088940e-06 1.127500000 1.716426e-06 1.128100000 1.418719e-06 1.128700000 1.179415e-06 1.129400000 9.574747e-07 1.130100000 7.830330e-07 1.130900000 6.276663e-07 1.131800000 4.946545e-07 1.132800000 3.844958e-07 1.133300000 3.406275e-07 1.133900000 2.957526e-07 1.134500000 2.579118e-07 1.135200000 2.210184e-07 1.135900000 1.904637e-07 1.136700000 1.617474e-07 1.137600000 1.356818e-07 1.138500000 1.147617e-07 1.139500000 9.616746e-08 1.140600000 8.003324e-08 1.141800000 6.631104e-08 1.143100000 5.483097e-08 1.144600000 4.476787e-08 1.146300000 3.629540e-08 1.148100000 2.969293e-08 1.150200000 2.409374e-08 1.152600000 1.955144e-08 1.155400000 1.587391e-08 1.158600000 1.301795e-08 1.162500000 1.071706e-08 1.167100000 8.979969e-09 1.172700000 7.666910e-09 1.182100000 6.460042e-09 1.194800000 5.706190e-09 1.212700000 5.281953e-09 1.240100000 5.086126e-09 2.000000000 5.023834e-09 ]
tran 1e-05 2.000000000002 0 1e-05
wrdata guasto_l41c$d v(mainjack) v(fixjack1) v(fixjack2)
wrdata guasto_l41c_stati$d v(xls.xs) v(xlp.xs) v(dep) v(ina) v(vplus) v(vminus) v(main_a) v(mainc) v(fixc1) v(fixc2)
destroy all
echo "guasto_l41c,guasto_l41c.dat,l41c_guasto,1000,0,10a0,100k,0.990000000,1000,2.000000000002,1e-05,evento,rif_guasto_l41c,-,0.0,6,A_ins" >> tb_v2_casopeggiore_manifest.csv
* ---- L41c: rif_guasto_u501_l41c (dal ponte: guasto_u501, giro 2) ----
alter vamp dc = 0
alter vfrq dc = 1000
alter rldm = 100k
alter rld1 = 100k
alter rld2 = 100k
alter vti dc = 1000
alter vtr dc = 2000
alter vtijk dc = 1000
alter vtrjk dc = 1000
alter vosa dc = 0
alter vosb dc = 0
alter vosf1 dc = 0
alter vosf2 dc = 0
alter ratth = 1m
alter rattb = 10k
alter rl1 = 845
alter cwire = 100p
alter vk1bi dc = 1
alter vk1bt dc = 1000.000000
alter vk5bi dc = 1
alter vk5bt dc = 1000.000000
alter vk1i dc = 0
alter vk1t dc = 1000.000000
alter vk5i dc = 0
alter vk5t dc = 1000.000000
alter vt1ri dc = 1
alter vt1rt dc = 1000.000000
alter vt1si dc = 0
alter vt1st dc = 1000.000000
alter vt2ri dc = 1
alter vt2rt dc = 1000.000000
alter vt2si dc = 0
alter vt2st dc = 1000.000000
alter vtijk dc = 1000.000000
alter vtrjk dc = 2000.000000
alter vksa dc = 1000.000000
alter vksb dc = 1000.001000
alter vkca dc = 1000.001000
alter vkcb dc = 1000.000000
alter vtiser dc = -10
alter vtrser dc = 1000
alter rbym = 1e12
alter rby1 = 1e12
alter rby2 = 1e12
alter rbcm = 220k
alter rbc1 = 470k
alter rbc2 = 470k
alter cksm = 0.1p
alter cks1 = 0.1p
alter cks2 = 0.1p
alter ccavm = 1e-18
alter ccav1 = 1e-18
alter ccav2 = 1e-18
print @cksm[capacitance] @cks1[capacitance] @cks2[capacitance] @ccavm[capacitance] @ccav1[capacitance] @ccav2[capacitance]
alter @vpp[pwl] = [ 0.000100000 14.999735 0.990000000 14.999735 2.000000000 14.999735 ]
alter @vmm[pwl] = [ 0.000100000 -15.052534 0.990000000 -15.052534 2.000000000 -15.052534 ]
alter @vpwl[pwl] = [ 0 1 1000 1 ]
alter @vis[pwl] = [ 0.000100000 1.201624e-02 0.990000000 1.201624e-02 2.000000000 1.201624e-02 ]
alter @vip[pwl] = [ 0.000100000 1.226115e-08 0.990000000 1.226115e-08 2.000000000 1.226115e-08 ]
tran 1e-05 2.000000000002 0 1e-05
wrdata rif_guasto_u501_l41c$d v(mainjack) v(fixjack1) v(fixjack2)
wrdata rif_guasto_u501_l41c_stati$d v(xls.xs) v(xlp.xs) v(dep) v(ina) v(vplus) v(vminus) v(main_a) v(mainc) v(fixc1) v(fixc2)
destroy all
echo "rif_guasto_u501_l41c,rif_guasto_u501_l41c.dat,rif,1000,0,10,100k,0.990000000,1000,2.000000000002,1e-05,rif_mai,-,-,0.0,0," >> tb_v2_casopeggiore_manifest.csv
* ---- L41c: guasto_u501_l41c (dal ponte: guasto_u501, giro 2) ----
alter vamp dc = 0
alter vfrq dc = 1000
alter rldm = 100k
alter rld1 = 100k
alter rld2 = 100k
alter vti dc = 1000
alter vtr dc = 2000
alter vtijk dc = 1.0131000000000001
alter vtrjk dc = 1000
alter vosa dc = 0
alter vosb dc = 0
alter vosf1 dc = 0
alter vosf2 dc = 0
alter ratth = 1m
alter rattb = 10k
alter rl1 = 845
alter cwire = 100p
alter vk1bi dc = 1
alter vk1bt dc = 1.030400
alter vk5bi dc = 1
alter vk5bt dc = 1.030700
alter vk1i dc = 0
alter vk1t dc = 1000.000000
alter vk5i dc = 0
alter vk5t dc = 1000.000000
alter vt1ri dc = 1
alter vt1rt dc = 1000.000000
alter vt1si dc = 0
alter vt1st dc = 1000.000000
alter vt2ri dc = 1
alter vt2rt dc = 1000.000000
alter vt2si dc = 0
alter vt2st dc = 1000.000000
alter vtijk dc = 1000.000000
alter vtrjk dc = 2000.000000
alter vksa dc = 1.013100
alter vksb dc = 1000.001000
alter vkca dc = 1.014100
alter vkcb dc = 1000.000000
alter vtiser dc = -10
alter vtrser dc = 1000
alter rbym = 1e12
alter rby1 = 1e12
alter rby2 = 1e12
alter rbcm = 220k
alter rbc1 = 470k
alter rbc2 = 470k
alter cksm = 0.1p
alter cks1 = 0.1p
alter cks2 = 0.1p
alter ccavm = 1e-18
alter ccav1 = 1e-18
alter ccav2 = 1e-18
print @cksm[capacitance] @cks1[capacitance] @cks2[capacitance] @ccavm[capacitance] @ccav1[capacitance] @ccav2[capacitance]
alter @vpp[pwl] = [ 0.000100000 14.999735 1.000000000 14.999735 1.000100000 14.977014 1.001000000 14.843001 1.001800000 14.724885 1.002700000 14.593128 1.003500000 14.477001 1.004400000 14.347462 1.005700000 14.162393 1.007100000 13.965758 1.008500000 13.771852 1.009900000 13.580639 1.011200000 13.405462 1.012600000 13.219336 1.013900000 13.048819 1.015300000 12.867645 1.016600000 12.701665 1.018000000 12.525311 1.019300000 12.363746 1.020700000 12.192084 1.022000000 12.034818 1.023400000 11.867723 1.024800000 11.702947 1.026200000 11.540459 1.027600000 11.380228 1.029000000 11.222221 1.030400000 11.066408 1.031800000 10.912758 1.033200000 10.761242 1.034600000 10.611829 1.036000000 10.464491 1.037500000 10.308898 1.038900000 10.165766 1.040400000 10.014614 1.041800000 9.875568 1.043300000 9.728732 1.044700000 9.593655 1.046200000 9.451010 1.047700000 9.310486 1.049200000 9.172052 1.050700000 9.035676 1.052200000 8.901328 1.053700000 8.768977 1.055200000 8.638594 1.056700000 8.510150 1.058200000 8.383616 1.059700000 8.258962 1.061300000 8.128041 1.062800000 8.007189 1.064400000 7.880259 1.066000000 7.755341 1.067600000 7.632403 1.069200000 7.511415 1.070800000 7.392344 1.072400000 7.275161 1.074000000 7.159835 1.075600000 7.046337 1.077200000 6.934639 1.078800000 6.824711 1.080500000 6.709822 1.082100000 6.603458 1.083800000 6.492293 1.085500000 6.383000 1.087200000 6.275546 1.088900000 6.169902 1.090600000 6.066035 1.092300000 5.963918 1.094000000 5.863519 1.095700000 5.764811 1.097500000 5.662107 1.099200000 5.566789 1.101000000 5.467613 1.102700000 5.375569 1.104500000 5.279800 1.106300000 5.185737 1.108100000 5.093349 1.109900000 5.002608 1.111700000 4.913483 1.113500000 4.825946 1.115400000 4.735237 1.117200000 4.650876 1.119100000 4.563458 1.120900000 4.482157 1.122800000 4.397910 1.124700000 4.315246 1.126600000 4.234137 1.128500000 4.154552 1.130500000 4.072393 1.132400000 3.995849 1.134400000 3.916829 1.136300000 3.843208 1.138300000 3.767207 1.140300000 3.692709 1.142300000 3.619684 1.144300000 3.548103 1.146300000 3.477938 1.148300000 3.409160 1.150400000 3.338407 1.152500000 3.269122 1.154600000 3.201275 1.156700000 3.134836 1.158800000 3.069776 1.160900000 3.006067 1.163100000 2.940741 1.165200000 2.879709 1.167400000 2.817130 1.169600000 2.755910 1.171800000 2.696020 1.174000000 2.637433 1.176300000 2.577542 1.178500000 2.521529 1.180800000 2.464271 1.183100000 2.408313 1.185400000 2.353626 1.187700000 2.300181 1.190100000 2.245705 1.192500000 2.192520 1.194900000 2.140594 1.197300000 2.089898 1.199700000 2.040402 1.202100000 1.992079 1.204600000 1.942959 1.207100000 1.895051 1.209600000 1.848323 1.212100000 1.802748 1.214700000 1.756541 1.217200000 1.713229 1.219800000 1.669317 1.222400000 1.626531 1.225100000 1.583259 1.227700000 1.542679 1.230400000 1.501638 1.235100000 1.432784 1.239800000 1.367087 1.244600000 1.303101 1.249500000 1.240869 1.254500000 1.180431 1.259600000 1.121815 1.264800000 1.065046 1.270000000 1.011150 1.275400000 0.958066 1.280800000 0.907769 1.286300000 0.859254 1.292000000 0.811709 1.297700000 0.766795 1.303600000 0.722921 1.309600000 0.680878 1.315700000 0.640639 1.321900000 0.602177 1.328300000 0.564895 1.334800000 0.529393 1.341400000 0.495626 1.348200000 0.463088 1.355100000 0.432254 1.362200000 0.402669 1.369400000 0.374734 1.376900000 0.347694 1.384500000 0.322284 1.392300000 0.298135 1.400300000 0.275245 1.408500000 0.253606 1.417000000 0.232970 1.425700000 0.213586 1.434700000 0.195230 1.443100000 0.179523 1.451700000 0.164752 1.460600000 0.150744 1.469700000 0.137652 1.479100000 0.125321 1.488800000 0.113754 1.498900000 0.102844 1.509300000 0.092703 1.531200000 0.074500 1.554800000 0.058866 1.580400000 0.045595 1.608400000 0.034483 1.637500000 0.025797 1.669800000 0.018696 1.705900000 0.013050 1.747000000 0.008671 1.793400000 0.005471 1.848200000 0.003183 2.000000000 0.000732 ]
alter @vmm[pwl] = [ 0.000100000 -15.052534 1.183200000 -15.052534 1.183300000 -15.050865 1.183400000 -15.046453 1.188600000 -14.798030 1.193700000 -14.558227 1.197600000 -14.377464 1.201500000 -14.198937 1.205700000 -14.009145 1.210000000 -13.817452 1.214300000 -13.628370 1.218600000 -13.441866 1.223000000 -13.253655 1.227500000 -13.063880 1.232000000 -12.876811 1.236500000 -12.692409 1.241000000 -12.510635 1.245600000 -12.327501 1.250100000 -12.150930 1.254700000 -11.973037 1.259300000 -11.797736 1.264000000 -11.621262 1.268700000 -11.447415 1.273400000 -11.276155 1.278100000 -11.107445 1.282900000 -10.937737 1.287600000 -10.774065 1.292400000 -10.609425 1.297200000 -10.447287 1.302000000 -10.287613 1.306900000 -10.127116 1.311800000 -9.969109 1.316700000 -9.813554 1.321600000 -9.660411 1.326600000 -9.506593 1.331600000 -9.355208 1.336600000 -9.206220 1.341700000 -9.056682 1.346800000 -8.909557 1.351900000 -8.764807 1.357000000 -8.622394 1.362200000 -8.479555 1.367400000 -8.339066 1.372600000 -8.200890 1.377800000 -8.064987 1.383100000 -7.928772 1.388400000 -7.794841 1.393800000 -7.660693 1.399100000 -7.531257 1.404500000 -7.401612 1.409900000 -7.274182 1.415400000 -7.146629 1.420900000 -7.021295 1.426400000 -6.898142 1.432000000 -6.774951 1.437600000 -6.653941 1.443200000 -6.535075 1.448900000 -6.416248 1.454600000 -6.299562 1.460300000 -6.184980 1.466100000 -6.070507 1.471900000 -5.958133 1.477700000 -5.847820 1.483600000 -5.737680 1.489500000 -5.629594 1.495500000 -5.521744 1.501500000 -5.415938 1.507500000 -5.312140 1.513500000 -5.210309 1.519600000 -5.108761 1.525700000 -5.009170 1.531800000 -4.911499 1.538000000 -4.814156 1.544200000 -4.718720 1.550400000 -4.625153 1.556700000 -4.531955 1.563000000 -4.440611 1.569400000 -4.349679 1.575800000 -4.260585 1.582300000 -4.171942 1.588800000 -4.085119 1.595400000 -3.998784 1.602000000 -3.914247 1.608700000 -3.830232 1.615400000 -3.747994 1.622200000 -3.666307 1.629000000 -3.586373 1.635800000 -3.508155 1.642700000 -3.430502 1.649600000 -3.354541 1.656600000 -3.279169 1.663700000 -3.204421 1.670800000 -3.131347 1.677900000 -3.059910 1.685100000 -2.989101 1.692400000 -2.918951 1.699700000 -2.850415 1.707100000 -2.782551 1.714600000 -2.715386 1.722100000 -2.649809 1.729700000 -2.584940 1.737300000 -2.521624 1.745000000 -2.459023 1.752700000 -2.397941 1.760500000 -2.337577 1.768400000 -2.277951 1.776300000 -2.219810 1.784300000 -2.162408 1.792400000 -2.105762 1.800500000 -2.050561 1.808700000 -1.996114 1.817000000 -1.942434 1.825300000 -1.890157 1.833700000 -1.838641 1.842200000 -1.787899 1.850800000 -1.737942 1.859500000 -1.688780 1.868200000 -1.640963 1.877000000 -1.593929 1.885900000 -1.547685 1.894900000 -1.502237 1.904000000 -1.457593 1.913200000 -1.413757 1.922400000 -1.371189 1.931800000 -1.328967 1.941200000 -1.287993 1.950800000 -1.247397 1.960400000 -1.208025 1.970100000 -1.169450 1.980000000 -1.131291 1.989900000 -1.094319 2.000000000 -1.057784 ]
alter @vpwl[pwl] = [ 0 1 1000 1 ]
alter @vis[pwl] = [ 0.000100000 1.201624e-02 1.010000000 1.201624e-02 1.010100000 1.165528e-02 1.010400000 9.674839e-03 1.010800000 7.507190e-03 1.011100000 6.188426e-03 1.011400000 5.093019e-03 1.011700000 4.187788e-03 1.012100000 3.225175e-03 1.012500000 2.486083e-03 1.012700000 2.184196e-03 1.013000000 1.800761e-03 1.013200000 1.584750e-03 1.013500000 1.310323e-03 1.013800000 1.085634e-03 1.014100000 9.014541e-04 1.014400000 7.502485e-04 1.014700000 6.259094e-04 1.015100000 4.934704e-04 1.015500000 3.908093e-04 1.015900000 3.109169e-04 1.016100000 2.777995e-04 1.016400000 2.351243e-04 1.016900000 1.790783e-04 1.017200000 1.526041e-04 1.017500000 1.303723e-04 1.017800000 1.116582e-04 1.018200000 9.116635e-05 1.018500000 7.852881e-05 1.018900000 6.460191e-05 1.019300000 5.336882e-05 1.019700000 4.427128e-05 1.020200000 3.524776e-05 1.020700000 2.823723e-05 1.021100000 2.374968e-05 1.021600000 1.923093e-05 1.022100000 1.566152e-05 1.022600000 1.282604e-05 1.023200000 1.016520e-05 1.023800000 8.117578e-06 1.024200000 7.015842e-06 1.024600000 6.082993e-06 1.025000000 5.290670e-06 1.025400000 4.615626e-06 1.025800000 4.038753e-06 1.026300000 3.432043e-06 1.026800000 2.929479e-06 1.027300000 2.511355e-06 1.027900000 2.099218e-06 1.028500000 1.765049e-06 1.029100000 1.492533e-06 1.029800000 1.235853e-06 1.030600000 1.004911e-06 1.031400000 8.245304e-07 1.032300000 6.668409e-07 1.033400000 5.217644e-07 1.034500000 4.142842e-07 1.035100000 3.674607e-07 1.035800000 3.210886e-07 1.036500000 2.820385e-07 1.037300000 2.446898e-07 1.038100000 2.136279e-07 1.039000000 1.846952e-07 1.040000000 1.584633e-07 1.041100000 1.352103e-07 1.042300000 1.149802e-07 1.043700000 9.647671e-08 1.045200000 8.116017e-08 1.046800000 6.857239e-08 1.048600000 5.775280e-08 1.050700000 4.829982e-08 1.053000000 4.066601e-08 1.055600000 3.436521e-08 1.058600000 2.914716e-08 1.062000000 2.497325e-08 1.066000000 2.157472e-08 1.070600000 1.892962e-08 1.076100000 1.684541e-08 1.082800000 1.524096e-08 1.094300000 1.374415e-08 1.110000000 1.285956e-08 1.113600000 1.075583e-08 1.117900000 9.096211e-09 1.123000000 7.833572e-09 1.129300000 6.868386e-09 1.144300000 5.774317e-09 1.167600000 5.236124e-09 1.240600000 5.028931e-09 2.000000000 5.023839e-09 ]
alter @vip[pwl] = [ 0.000100000 1.226115e-08 1.010000000 1.226115e-08 1.010100000 1.268999e-08 1.010500000 1.656768e-08 1.011000000 2.326328e-08 1.011300000 2.855518e-08 1.011500000 3.273564e-08 1.011900000 4.298262e-08 1.012200000 5.264732e-08 1.012400000 6.021443e-08 1.012700000 7.353346e-08 1.012900000 8.391101e-08 1.013200000 1.020924e-07 1.013400000 1.161938e-07 1.013800000 1.499931e-07 1.014200000 1.927169e-07 1.014500000 2.318338e-07 1.014900000 2.953440e-07 1.015200000 3.530148e-07 1.015500000 4.207845e-07 1.015800000 5.001889e-07 1.016300000 6.631748e-07 1.016800000 8.727459e-07 1.017300000 1.140155e-06 1.017800000 1.478855e-06 1.018200000 1.811761e-06 1.018600000 2.209865e-06 1.019000000 2.683847e-06 1.019400000 3.245748e-06 1.019700000 3.732938e-06 1.020100000 4.482122e-06 1.020400000 5.127701e-06 1.020800000 6.114345e-06 1.021100000 6.959415e-06 1.021700000 8.959030e-06 1.022300000 1.143852e-05 1.022900000 1.448816e-05 1.023400000 1.753812e-05 1.023900000 2.111943e-05 1.024400000 2.530329e-05 1.024900000 3.016631e-05 1.025600000 3.827410e-05 1.026300000 4.812155e-05 1.027000000 5.997558e-05 1.027600000 7.194965e-05 1.028200000 8.579796e-05 1.028800000 1.017191e-04 1.029400000 1.199180e-04 1.030000000 1.406044e-04 1.031100000 1.856972e-04 1.032100000 2.356709e-04 1.033100000 2.951907e-04 1.034100000 3.651632e-04 1.035100000 4.464126e-04 1.036000000 5.297704e-04 1.037900000 7.394460e-04 1.039800000 9.966744e-04 1.041700000 1.301668e-03 1.044700000 1.874628e-03 1.048000000 2.613402e-03 1.060300000 5.747574e-03 1.066100000 7.097672e-03 1.072300000 8.310868e-03 1.078700000 9.300736e-03 1.085400000 1.008201e-02 1.092600000 1.068733e-02 1.110000000 1.149359e-02 1.110300000 9.562363e-03 1.110600000 7.907949e-03 1.110900000 6.520642e-03 1.111300000 5.026192e-03 1.111600000 4.128882e-03 1.112000000 3.174546e-03 1.112400000 2.441946e-03 1.112600000 2.142831e-03 1.112900000 1.763122e-03 1.113100000 1.549341e-03 1.113400000 1.278001e-03 1.113600000 1.125170e-03 1.113900000 9.310033e-04 1.114200000 7.719346e-04 1.114500000 6.414359e-04 1.114900000 5.028573e-04 1.115300000 3.958537e-04 1.115700000 3.129389e-04 1.115900000 2.786870e-04 1.116200000 2.346789e-04 1.116400000 2.095529e-04 1.116700000 1.771718e-04 1.116900000 1.586259e-04 1.117200000 1.346503e-04 1.117500000 1.145708e-04 1.117800000 9.771562e-05 1.118100000 8.353504e-05 1.118500000 6.801980e-05 1.118900000 5.561110e-05 1.119300000 4.564775e-05 1.119800000 3.586186e-05 1.120300000 2.834307e-05 1.120700000 2.357947e-05 1.121100000 1.968877e-05 1.121600000 1.579521e-05 1.122100000 1.274158e-05 1.122700000 9.915967e-06 1.123300000 7.775143e-06 1.123600000 6.903809e-06 1.124000000 5.908456e-06 1.124700000 4.533183e-06 1.125100000 3.912578e-06 1.125500000 3.386961e-06 1.125900000 2.940488e-06 1.126400000 2.474105e-06 1.126900000 2.090756e-06 1.127500000 1.717876e-06 1.128100000 1.419883e-06 1.128700000 1.180355e-06 1.129400000 9.582115e-07 1.130100000 7.836146e-07 1.130900000 6.281144e-07 1.131800000 4.949920e-07 1.132800000 3.847455e-07 1.133300000 3.408441e-07 1.133900000 2.959351e-07 1.134500000 2.580663e-07 1.135200000 2.211462e-07 1.135900000 1.905700e-07 1.136700000 1.618342e-07 1.137600000 1.357512e-07 1.138500000 1.148178e-07 1.139500000 9.621215e-08 1.140600000 8.006831e-08 1.141800000 6.633841e-08 1.143100000 5.485212e-08 1.144600000 4.478384e-08 1.146300000 3.630723e-08 1.148100000 2.970173e-08 1.150200000 2.410011e-08 1.152600000 1.955598e-08 1.155400000 1.587707e-08 1.158600000 1.302014e-08 1.162500000 1.071852e-08 1.167100000 8.980938e-09 1.172700000 7.667541e-09 1.182100000 6.460401e-09 1.194800000 5.706374e-09 1.212700000 5.282045e-09 1.240100000 5.086176e-09 2.000000000 5.023838e-09 ]
tran 1e-05 2.000000000002 0 1e-05
wrdata guasto_u501_l41c$d v(mainjack) v(fixjack1) v(fixjack2)
wrdata guasto_u501_l41c_stati$d v(xls.xs) v(xlp.xs) v(dep) v(ina) v(vplus) v(vminus) v(main_a) v(mainc) v(fixc1) v(fixc2)
destroy all
echo "guasto_u501_l41c,guasto_u501_l41c.dat,l41c_guasto_u501,1000,0,10a0,100k,0.990000000,1000,2.000000000002,1e-05,evento,rif_guasto_u501_l41c,-,0.0,6,A_ins" >> tb_v2_casopeggiore_manifest.csv
* ---- L41c: rif_guasto_u503_l41c (dal ponte: guasto_u503, giro 2) ----
alter vamp dc = 0
alter vfrq dc = 1000
alter rldm = 100k
alter rld1 = 100k
alter rld2 = 100k
alter vti dc = 1000
alter vtr dc = 2000
alter vtijk dc = 1000
alter vtrjk dc = 1000
alter vosa dc = 0
alter vosb dc = 0
alter vosf1 dc = 0
alter vosf2 dc = 0
alter ratth = 1m
alter rattb = 10k
alter rl1 = 845
alter cwire = 100p
alter vk1bi dc = 1
alter vk1bt dc = 1000.000000
alter vk5bi dc = 1
alter vk5bt dc = 1000.000000
alter vk1i dc = 0
alter vk1t dc = 1000.000000
alter vk5i dc = 0
alter vk5t dc = 1000.000000
alter vt1ri dc = 1
alter vt1rt dc = 1000.000000
alter vt1si dc = 0
alter vt1st dc = 1000.000000
alter vt2ri dc = 1
alter vt2rt dc = 1000.000000
alter vt2si dc = 0
alter vt2st dc = 1000.000000
alter vtijk dc = 1000.000000
alter vtrjk dc = 2000.000000
alter vksa dc = 1000.000000
alter vksb dc = 1000.001000
alter vkca dc = 1000.001000
alter vkcb dc = 1000.000000
alter vtiser dc = -10
alter vtrser dc = 1000
alter rbym = 1e12
alter rby1 = 1e12
alter rby2 = 1e12
alter rbcm = 220k
alter rbc1 = 470k
alter rbc2 = 470k
alter cksm = 0.1p
alter cks1 = 0.1p
alter cks2 = 0.1p
alter ccavm = 1e-18
alter ccav1 = 1e-18
alter ccav2 = 1e-18
print @cksm[capacitance] @cks1[capacitance] @cks2[capacitance] @ccavm[capacitance] @ccav1[capacitance] @ccav2[capacitance]
alter @vpp[pwl] = [ 0.000100000 14.999735 0.990000000 14.999735 2.000000000 14.999735 ]
alter @vmm[pwl] = [ 0.000100000 -15.052534 0.990000000 -15.052534 2.000000000 -15.052534 ]
alter @vpwl[pwl] = [ 0 1 1000 1 ]
alter @vis[pwl] = [ 0.000100000 1.201624e-02 0.990000000 1.201625e-02 2.000000000 1.201625e-02 ]
alter @vip[pwl] = [ 0.000100000 1.226115e-08 0.990000000 1.226115e-08 2.000000000 1.226115e-08 ]
tran 1e-05 2.000000000002 0 1e-05
wrdata rif_guasto_u503_l41c$d v(mainjack) v(fixjack1) v(fixjack2)
wrdata rif_guasto_u503_l41c_stati$d v(xls.xs) v(xlp.xs) v(dep) v(ina) v(vplus) v(vminus) v(main_a) v(mainc) v(fixc1) v(fixc2)
destroy all
echo "rif_guasto_u503_l41c,rif_guasto_u503_l41c.dat,rif,1000,0,10,100k,0.990000000,1000,2.000000000002,1e-05,rif_mai,-,-,0.0,0," >> tb_v2_casopeggiore_manifest.csv
* ---- L41c: guasto_u503_l41c (dal ponte: guasto_u503, giro 2) ----
alter vamp dc = 0
alter vfrq dc = 1000
alter rldm = 100k
alter rld1 = 100k
alter rld2 = 100k
alter vti dc = 1000
alter vtr dc = 2000
alter vtijk dc = 1.0158
alter vtrjk dc = 1000
alter vosa dc = 0
alter vosb dc = 0
alter vosf1 dc = 0
alter vosf2 dc = 0
alter ratth = 1m
alter rattb = 10k
alter rl1 = 845
alter cwire = 100p
alter vk1bi dc = 1
alter vk1bt dc = 1.033100
alter vk5bi dc = 1
alter vk5bt dc = 1.033400
alter vk1i dc = 0
alter vk1t dc = 1000.000000
alter vk5i dc = 0
alter vk5t dc = 1000.000000
alter vt1ri dc = 1
alter vt1rt dc = 1000.000000
alter vt1si dc = 0
alter vt1st dc = 1000.000000
alter vt2ri dc = 1
alter vt2rt dc = 1000.000000
alter vt2si dc = 0
alter vt2st dc = 1000.000000
alter vtijk dc = 1000.000000
alter vtrjk dc = 2000.000000
alter vksa dc = 1.015800
alter vksb dc = 1000.001000
alter vkca dc = 1.016800
alter vkcb dc = 1000.000000
alter vtiser dc = -10
alter vtrser dc = 1000
alter rbym = 1e12
alter rby1 = 1e12
alter rby2 = 1e12
alter rbcm = 220k
alter rbc1 = 470k
alter rbc2 = 470k
alter cksm = 0.1p
alter cks1 = 0.1p
alter cks2 = 0.1p
alter ccavm = 1e-18
alter ccav1 = 1e-18
alter ccav2 = 1e-18
print @cksm[capacitance] @cks1[capacitance] @cks2[capacitance] @ccavm[capacitance] @ccav1[capacitance] @ccav2[capacitance]
alter @vpp[pwl] = [ 0.000100000 14.999735 1.144400000 14.999735 1.144500000 14.997358 1.144600000 14.992880 1.149700000 14.750395 1.154700000 14.516368 1.158800000 14.327232 1.163000000 14.136033 1.167400000 13.938458 1.171900000 13.739243 1.176300000 13.547202 1.180800000 13.353565 1.185400000 13.158479 1.190000000 12.966237 1.194600000 12.776795 1.199200000 12.590115 1.203900000 12.402186 1.208600000 12.217055 1.213300000 12.034680 1.218000000 11.855020 1.222800000 11.674298 1.227600000 11.496324 1.232400000 11.321055 1.237300000 11.144883 1.242200000 10.971444 1.247100000 10.800697 1.252000000 10.632599 1.257000000 10.463758 1.262000000 10.297591 1.267000000 10.134054 1.272000000 9.973106 1.277100000 9.811564 1.282200000 9.652630 1.287300000 9.496261 1.292400000 9.342418 1.297600000 9.188114 1.302800000 9.036350 1.308000000 8.887085 1.313300000 8.737476 1.318600000 8.590377 1.323900000 8.445745 1.329200000 8.303538 1.334600000 8.161102 1.340000000 8.021099 1.345400000 7.883488 1.350900000 7.745746 1.356400000 7.610400 1.362000000 7.475013 1.367600000 7.342024 1.373200000 7.211391 1.378800000 7.083072 1.384500000 6.954795 1.390200000 6.828830 1.396000000 6.702987 1.401800000 6.579451 1.407600000 6.458181 1.413400000 6.339135 1.419300000 6.220277 1.425200000 6.103636 1.431200000 5.987248 1.437200000 5.873069 1.443200000 5.761055 1.449300000 5.649351 1.455400000 5.539802 1.461600000 5.430620 1.467800000 5.323578 1.474000000 5.218632 1.480300000 5.114101 1.486600000 5.011649 1.492900000 4.911238 1.499200000 4.812825 1.505600000 4.714855 1.512100000 4.617382 1.518600000 4.521910 1.525100000 4.428398 1.531700000 4.335412 1.538300000 4.244364 1.545000000 4.153877 1.551700000 4.065305 1.558500000 3.977326 1.565300000 3.891236 1.572100000 3.806995 1.579000000 3.723363 1.586000000 3.640380 1.593000000 3.559230 1.600100000 3.478752 1.607200000 3.400077 1.614400000 3.322095 1.621600000 3.245883 1.628900000 3.170381 1.636200000 3.096617 1.643600000 3.023576 1.651100000 2.951287 1.658600000 2.880708 1.666200000 2.810891 1.673800000 2.742747 1.681500000 2.675372 1.689300000 2.608788 1.697100000 2.543842 1.705000000 2.479691 1.713000000 2.416355 1.721000000 2.354615 1.729100000 2.293690 1.737200000 2.234319 1.745400000 2.175758 1.753700000 2.118023 1.762100000 2.061130 1.770500000 2.005741 1.779000000 1.951184 1.787600000 1.897471 1.796300000 1.844613 1.805100000 1.792620 1.814000000 1.741500 1.822900000 1.691812 1.831900000 1.642981 1.841000000 1.595012 1.850200000 1.547913 1.859500000 1.501686 1.868900000 1.456335 1.878300000 1.412325 1.887900000 1.368721 1.897500000 1.326432 1.907200000 1.284999 1.917100000 1.244014 1.927000000 1.204303 1.937100000 1.165063 1.947300000 1.126697 1.957600000 1.089202 1.968000000 1.052572 1.978600000 1.016469 1.989200000 0.981567 2.000000000 0.947200 ]
alter @vmm[pwl] = [ 0.000100000 -15.052534 1.143200000 -15.052534 1.143300000 -15.050783 1.143400000 -15.046367 1.148700000 -14.793205 1.153800000 -14.553480 1.157900000 -14.363570 1.162000000 -14.176127 1.166400000 -13.977679 1.170800000 -13.781997 1.175200000 -13.589044 1.179700000 -13.394488 1.184300000 -13.198475 1.188900000 -13.005317 1.193500000 -12.814975 1.198200000 -12.623359 1.202900000 -12.434595 1.207600000 -12.248641 1.212300000 -12.065455 1.217000000 -11.884996 1.221800000 -11.703469 1.226600000 -11.524702 1.231400000 -11.348652 1.236300000 -11.171694 1.241200000 -10.997482 1.246100000 -10.825972 1.251000000 -10.657123 1.256000000 -10.487528 1.261000000 -10.320617 1.266000000 -10.156349 1.271000000 -9.994680 1.276100000 -9.832414 1.281200000 -9.672767 1.286300000 -9.515698 1.291400000 -9.361163 1.296600000 -9.206167 1.301800000 -9.053721 1.307000000 -8.903784 1.312300000 -8.753503 1.317600000 -8.605741 1.322900000 -8.460458 1.328300000 -8.314939 1.333700000 -8.171905 1.339100000 -8.031316 1.344500000 -7.893128 1.350000000 -7.754807 1.355500000 -7.618893 1.361100000 -7.482937 1.366700000 -7.349388 1.372300000 -7.218205 1.377900000 -7.089345 1.383600000 -6.960528 1.389300000 -6.834032 1.395100000 -6.707657 1.400900000 -6.583600 1.406700000 -6.461818 1.412500000 -6.342268 1.418400000 -6.222907 1.424300000 -6.105771 1.430300000 -5.988891 1.436300000 -5.874226 1.442400000 -5.759880 1.448500000 -5.647738 1.454600000 -5.537758 1.460800000 -5.428147 1.467000000 -5.320683 1.473200000 -5.215324 1.479500000 -5.110380 1.485800000 -5.007524 1.492100000 -4.906716 1.498400000 -4.807914 1.504800000 -4.709557 1.511300000 -4.611698 1.517800000 -4.515847 1.524300000 -4.421965 1.530900000 -4.328609 1.537500000 -4.237199 1.544200000 -4.146353 1.550900000 -4.057428 1.557700000 -3.969099 1.564500000 -3.882665 1.571400000 -3.796857 1.578300000 -3.712918 1.585300000 -3.629630 1.592300000 -3.548181 1.599400000 -3.467407 1.606500000 -3.388442 1.613700000 -3.310171 1.620900000 -3.233678 1.628200000 -3.157896 1.635600000 -3.082857 1.643000000 -3.009568 1.650500000 -2.937035 1.658000000 -2.866216 1.665600000 -2.796162 1.673200000 -2.727786 1.680900000 -2.660181 1.688700000 -2.593370 1.696600000 -2.527377 1.704500000 -2.463027 1.712500000 -2.399494 1.720500000 -2.337563 1.728600000 -2.276448 1.736700000 -2.216892 1.745000000 -2.157442 1.753300000 -2.099545 1.761700000 -2.042492 1.770100000 -1.986947 1.778600000 -1.932237 1.787200000 -1.878373 1.795900000 -1.825366 1.804700000 -1.773227 1.813600000 -1.721963 1.822500000 -1.672135 1.831600000 -1.622630 1.840700000 -1.574541 1.849900000 -1.527324 1.859200000 -1.480981 1.868600000 -1.435518 1.878100000 -1.390935 1.887700000 -1.347236 1.897300000 -1.304855 1.907100000 -1.262910 1.917000000 -1.221849 1.927000000 -1.181669 1.937100000 -1.142368 1.947300000 -1.103943 1.957600000 -1.066390 1.968000000 -1.029705 1.978600000 -0.993547 1.989200000 -0.958591 2.000000000 -0.924171 ]
alter @vpwl[pwl] = [ 0 1 1000 1 ]
alter @vis[pwl] = [ 0.000100000 1.201624e-02 1.012700000 1.201625e-02 1.013100000 9.554084e-03 1.013400000 7.901097e-03 1.013700000 6.516747e-03 1.014000000 5.365200e-03 1.014400000 4.133434e-03 1.014800000 3.183367e-03 1.015200000 2.454040e-03 1.015400000 2.156163e-03 1.015700000 1.777838e-03 1.015900000 1.564693e-03 1.016200000 1.293909e-03 1.016500000 1.072207e-03 1.016800000 8.904316e-04 1.017100000 7.411897e-04 1.017400000 6.184527e-04 1.017800000 4.877001e-04 1.018200000 3.863269e-04 1.018600000 3.074232e-04 1.018800000 2.747090e-04 1.019100000 2.325461e-04 1.019600000 1.771649e-04 1.019900000 1.509971e-04 1.020200000 1.290219e-04 1.020500000 1.105200e-04 1.020900000 9.025619e-05 1.021200000 7.775794e-05 1.021600000 6.398132e-05 1.022000000 5.286715e-05 1.022400000 4.386409e-05 1.022900000 3.493243e-05 1.023400000 2.799142e-05 1.023800000 2.354730e-05 1.024300000 1.907149e-05 1.024800000 1.553519e-05 1.025300000 1.272539e-05 1.025900000 1.008798e-05 1.026600000 7.767410e-06 1.027000000 6.719654e-06 1.027400000 5.831688e-06 1.027800000 5.076784e-06 1.028200000 4.433033e-06 1.028600000 3.882423e-06 1.029100000 3.302757e-06 1.029600000 2.822078e-06 1.030100000 2.421741e-06 1.030700000 2.026723e-06 1.031300000 1.706057e-06 1.031900000 1.444259e-06 1.032600000 1.197383e-06 1.033400000 9.749782e-07 1.034200000 8.010265e-07 1.035100000 6.487514e-07 1.036200000 5.084438e-07 1.037300000 4.043341e-07 1.037900000 3.589247e-07 1.038600000 3.139153e-07 1.039300000 2.759786e-07 1.040100000 2.396626e-07 1.040900000 2.094317e-07 1.041800000 1.812469e-07 1.043100000 1.489708e-07 1.044500000 1.225172e-07 1.046100000 9.981006e-08 1.047900000 8.098140e-08 1.049900000 6.577183e-08 1.052300000 5.280473e-08 1.055100000 4.237687e-08 1.058300000 3.432409e-08 1.061600000 2.868724e-08 1.065400000 2.426098e-08 1.069900000 2.076631e-08 1.075400000 1.801682e-08 1.081800000 1.602536e-08 1.089700000 1.455665e-08 1.099500000 1.353979e-08 1.112000000 1.288316e-08 1.114800000 1.117135e-08 1.118000000 9.754857e-09 1.121700000 8.591592e-09 1.125900000 7.669706e-09 1.136200000 6.169667e-09 1.147100000 5.214035e-09 1.162700000 4.430180e-09 1.185400000 3.726818e-09 1.420600000 2.581182e-09 1.761900000 1.252407e-09 1.807300000 2.271779e-09 1.923600000 4.249938e-09 2.000000000 6.323242e-09 ]
alter @vip[pwl] = [ 0.000100000 1.226115e-08 1.012700000 1.226115e-08 1.012900000 1.373769e-08 1.013200000 1.679247e-08 1.013700000 2.358298e-08 1.014100000 3.099513e-08 1.014500000 4.070994e-08 1.014800000 4.988287e-08 1.015000000 5.707051e-08 1.015300000 6.973154e-08 1.015500000 7.960490e-08 1.015800000 9.691324e-08 1.016000000 1.103481e-07 1.016400000 1.425810e-07 1.016800000 1.833672e-07 1.017100000 2.207468e-07 1.017500000 2.814954e-07 1.017800000 3.367097e-07 1.018100000 4.016442e-07 1.018400000 4.777856e-07 1.018900000 6.342386e-07 1.019400000 8.356475e-07 1.019900000 1.092946e-06 1.020400000 1.419243e-06 1.020800000 1.740278e-06 1.021200000 2.124530e-06 1.021600000 2.582418e-06 1.022000000 3.125702e-06 1.022300000 3.597093e-06 1.022700000 4.322533e-06 1.023000000 4.948053e-06 1.023400000 5.904724e-06 1.023700000 6.724655e-06 1.024300000 8.666506e-06 1.024900000 1.107704e-05 1.025500000 1.404503e-05 1.026000000 1.701610e-05 1.026500000 2.050789e-05 1.027000000 2.459030e-05 1.027500000 2.933925e-05 1.028200000 3.726425e-05 1.028900000 4.689987e-05 1.029600000 5.851041e-05 1.030200000 7.024888e-05 1.030800000 8.383594e-05 1.031400000 9.946894e-05 1.032000000 1.173521e-04 1.032600000 1.376947e-04 1.033700000 1.820831e-04 1.034700000 2.313345e-04 1.035700000 2.900564e-04 1.036700000 3.591608e-04 1.037700000 4.394804e-04 1.038600000 5.219563e-04 1.040500000 7.296686e-04 1.042400000 9.848741e-04 1.044300000 1.287884e-03 1.047300000 1.858013e-03 1.050600000 2.594403e-03 1.062900000 5.727745e-03 1.068700000 7.080379e-03 1.074900000 8.296834e-03 1.081300000 9.289919e-03 1.087900000 1.006402e-02 1.095000000 1.066757e-02 1.112000000 1.147394e-02 1.112300000 9.545560e-03 1.112600000 7.893809e-03 1.112900000 6.508938e-03 1.113300000 5.016974e-03 1.113600000 4.121260e-03 1.114000000 3.168684e-03 1.114400000 2.437454e-03 1.114600000 2.138903e-03 1.114900000 1.759910e-03 1.115100000 1.546535e-03 1.115400000 1.275707e-03 1.115600000 1.123164e-03 1.115900000 9.293604e-04 1.116200000 7.705878e-04 1.116500000 6.403326e-04 1.116900000 5.020067e-04 1.117300000 3.951957e-04 1.117700000 3.124281e-04 1.117900000 2.782362e-04 1.118200000 2.343046e-04 1.118400000 2.092218e-04 1.118700000 1.768958e-04 1.118900000 1.583813e-04 1.119200000 1.344460e-04 1.119500000 1.143995e-04 1.119800000 9.757165e-05 1.120100000 8.341268e-05 1.120500000 6.792241e-05 1.120900000 5.553283e-05 1.121300000 4.558485e-05 1.121800000 3.581367e-05 1.122300000 2.830607e-05 1.122700000 2.354931e-05 1.123100000 1.966410e-05 1.123600000 1.577592e-05 1.124100000 1.272651e-05 1.124600000 1.032174e-05 1.125200000 8.083601e-06 1.125500000 7.173482e-06 1.125900000 6.134521e-06 1.126600000 4.700457e-06 1.127000000 4.053994e-06 1.127400000 3.506870e-06 1.127800000 3.042457e-06 1.128300000 2.557708e-06 1.128800000 2.159598e-06 1.129400000 1.772704e-06 1.130000000 1.463808e-06 1.130600000 1.214120e-06 1.131300000 9.800887e-07 1.132000000 7.970411e-07 1.132800000 6.348407e-07 1.133700000 4.967674e-07 1.134700000 3.831311e-07 1.135200000 3.381039e-07 1.135800000 2.922041e-07 1.136400000 2.536454e-07 1.137100000 2.162035e-07 1.137800000 1.853270e-07 1.138600000 1.564385e-07 1.139400000 1.329610e-07 1.140300000 1.116097e-07 1.141300000 9.274993e-08 1.142400000 7.649414e-08 1.143600000 6.276578e-08 1.144900000 5.136458e-08 1.146400000 4.144844e-08 1.148100000 3.316959e-08 1.149900000 2.677294e-08 1.152000000 2.139481e-08 1.154400000 1.706970e-08 1.157100000 1.369946e-08 1.160300000 1.098730e-08 1.164200000 8.814142e-09 1.168900000 7.144831e-09 1.174600000 5.882375e-09 1.183800000 4.709574e-09 1.192500000 4.220089e-09 1.209100000 3.776435e-09 1.234500000 3.482459e-09 1.762000000 1.252408e-09 1.807300000 2.271779e-09 1.923700000 4.252067e-09 2.000000000 6.323242e-09 ]
tran 1e-05 2.000000000002 0 1e-05
wrdata guasto_u503_l41c$d v(mainjack) v(fixjack1) v(fixjack2)
wrdata guasto_u503_l41c_stati$d v(xls.xs) v(xlp.xs) v(dep) v(ina) v(vplus) v(vminus) v(main_a) v(mainc) v(fixc1) v(fixc2)
destroy all
echo "guasto_u503_l41c,guasto_u503_l41c.dat,l41c_guasto_u503,1000,0,10a0,100k,0.990000000,1000,2.000000000002,1e-05,evento,rif_guasto_u503_l41c,-,0.0,6,A_ins" >> tb_v2_casopeggiore_manifest.csv
* ---- L41c: rif_guasto_u503_min_l41c (dal ponte: guasto_u503_min, giro 2) ----
alter vamp dc = 0
alter vfrq dc = 1000
alter rldm = 100k
alter rld1 = 100k
alter rld2 = 100k
alter vti dc = 1000
alter vtr dc = 2000
alter vtijk dc = 1000
alter vtrjk dc = 1000
alter vosa dc = 0
alter vosb dc = 0
alter vosf1 dc = 0
alter vosf2 dc = 0
alter ratth = 1m
alter rattb = 10k
alter rl1 = 845
alter cwire = 100p
alter vk1bi dc = 1
alter vk1bt dc = 1000.000000
alter vk5bi dc = 1
alter vk5bt dc = 1000.000000
alter vk1i dc = 0
alter vk1t dc = 1000.000000
alter vk5i dc = 0
alter vk5t dc = 1000.000000
alter vt1ri dc = 1
alter vt1rt dc = 1000.000000
alter vt1si dc = 0
alter vt1st dc = 1000.000000
alter vt2ri dc = 1
alter vt2rt dc = 1000.000000
alter vt2si dc = 0
alter vt2st dc = 1000.000000
alter vtijk dc = 1000.000000
alter vtrjk dc = 2000.000000
alter vksa dc = 1000.000000
alter vksb dc = 1000.001000
alter vkca dc = 1000.001000
alter vkcb dc = 1000.000000
alter vtiser dc = -10
alter vtrser dc = 1000
alter rbym = 1e12
alter rby1 = 1e12
alter rby2 = 1e12
alter rbcm = 220k
alter rbc1 = 470k
alter rbc2 = 470k
alter cksm = 0.1p
alter cks1 = 0.1p
alter cks2 = 0.1p
alter ccavm = 1e-18
alter ccav1 = 1e-18
alter ccav2 = 1e-18
print @cksm[capacitance] @cks1[capacitance] @cks2[capacitance] @ccavm[capacitance] @ccav1[capacitance] @ccav2[capacitance]
alter @vpp[pwl] = [ 0.000100000 14.999735 0.990000000 14.999735 2.000000000 14.999735 ]
alter @vmm[pwl] = [ 0.000100000 -15.052534 0.990000000 -15.052534 2.000000000 -15.052534 ]
alter @vpwl[pwl] = [ 0 1 1000 1 ]
alter @vis[pwl] = [ 0.000100000 1.167331e-02 0.990000000 1.167331e-02 2.000000000 1.167331e-02 ]
alter @vip[pwl] = [ 0.000100000 1.188839e-08 0.990000000 1.188839e-08 2.000000000 1.188839e-08 ]
tran 1e-05 2.000000000002 0 1e-05
wrdata rif_guasto_u503_min_l41c$d v(mainjack) v(fixjack1) v(fixjack2)
wrdata rif_guasto_u503_min_l41c_stati$d v(xls.xs) v(xlp.xs) v(dep) v(ina) v(vplus) v(vminus) v(main_a) v(mainc) v(fixc1) v(fixc2)
destroy all
echo "rif_guasto_u503_min_l41c,rif_guasto_u503_min_l41c.dat,rif,1000,0,10,100k,0.990000000,1000,2.000000000002,1e-05,rif_mai,-,-,0.0,0," >> tb_v2_casopeggiore_manifest.csv
* ---- L41c: guasto_u503_min_l41c (dal ponte: guasto_u503_min, giro 2) ----
alter vamp dc = 0
alter vfrq dc = 1000
alter rldm = 100k
alter rld1 = 100k
alter rld2 = 100k
alter vti dc = 1000
alter vtr dc = 2000
alter vtijk dc = 1.0156
alter vtrjk dc = 1000
alter vosa dc = 0
alter vosb dc = 0
alter vosf1 dc = 0
alter vosf2 dc = 0
alter ratth = 1m
alter rattb = 10k
alter rl1 = 845
alter cwire = 100p
alter vk1bi dc = 1
alter vk1bt dc = 1.031600
alter vk5bi dc = 1
alter vk5bt dc = 1.031900
alter vk1i dc = 0
alter vk1t dc = 1000.000000
alter vk5i dc = 0
alter vk5t dc = 1000.000000
alter vt1ri dc = 1
alter vt1rt dc = 1000.000000
alter vt1si dc = 0
alter vt1st dc = 1000.000000
alter vt2ri dc = 1
alter vt2rt dc = 1000.000000
alter vt2si dc = 0
alter vt2st dc = 1000.000000
alter vtijk dc = 1000.000000
alter vtrjk dc = 2000.000000
alter vksa dc = 1.015600
alter vksb dc = 1000.001000
alter vkca dc = 1.016600
alter vkcb dc = 1000.000000
alter vtiser dc = -10
alter vtrser dc = 1000
alter rbym = 1e12
alter rby1 = 1e12
alter rby2 = 1e12
alter rbcm = 220k
alter rbc1 = 470k
alter rbc2 = 470k
alter cksm = 0.1p
alter cks1 = 0.1p
alter cks2 = 0.1p
alter ccavm = 1e-18
alter ccav1 = 1e-18
alter ccav2 = 1e-18
print @cksm[capacitance] @cks1[capacitance] @cks2[capacitance] @ccavm[capacitance] @ccav1[capacitance] @ccav2[capacitance]
alter @vpp[pwl] = [ 0.000100000 14.999735 1.144400000 14.999735 1.144500000 14.997303 1.144600000 14.992820 1.149700000 14.750336 1.154700000 14.516309 1.158800000 14.327174 1.163000000 14.135975 1.167400000 13.938402 1.171900000 13.739188 1.176300000 13.547147 1.180800000 13.353511 1.185400000 13.158426 1.190000000 12.966184 1.194600000 12.776744 1.199200000 12.590064 1.203900000 12.402136 1.208600000 12.217006 1.213300000 12.034631 1.218000000 11.854972 1.222800000 11.674251 1.227600000 11.496278 1.232400000 11.321009 1.237300000 11.144838 1.242200000 10.971400 1.247100000 10.800653 1.252000000 10.632556 1.257000000 10.463716 1.262000000 10.297549 1.267000000 10.134013 1.272000000 9.973066 1.277100000 9.811524 1.282200000 9.652591 1.287300000 9.496223 1.292400000 9.342380 1.297600000 9.188077 1.302800000 9.036314 1.308000000 8.887049 1.313300000 8.737441 1.318600000 8.590342 1.323900000 8.445710 1.329200000 8.303505 1.334600000 8.161069 1.340000000 8.021067 1.345400000 7.883456 1.350900000 7.745715 1.356400000 7.610369 1.362000000 7.474983 1.367600000 7.341994 1.373200000 7.211362 1.378800000 7.083043 1.384500000 6.954767 1.390200000 6.828803 1.396000000 6.702960 1.401800000 6.579425 1.407600000 6.458155 1.413400000 6.339110 1.419300000 6.220252 1.425200000 6.103611 1.431200000 5.987224 1.437200000 5.873045 1.443200000 5.761031 1.449300000 5.649328 1.455400000 5.539779 1.461600000 5.430598 1.467800000 5.323556 1.474000000 5.218611 1.480300000 5.114080 1.486600000 5.011629 1.492900000 4.911218 1.499200000 4.812805 1.505600000 4.714836 1.512100000 4.617363 1.518600000 4.521892 1.525100000 4.428380 1.531700000 4.335394 1.538300000 4.244347 1.545000000 4.153860 1.551700000 4.065288 1.558500000 3.977310 1.565300000 3.891221 1.572100000 3.806979 1.579000000 3.723348 1.586000000 3.640365 1.593000000 3.559216 1.600100000 3.478738 1.607200000 3.400064 1.614400000 3.322081 1.621600000 3.245870 1.628900000 3.170368 1.636200000 3.096604 1.643600000 3.023563 1.651100000 2.951275 1.658600000 2.880697 1.666200000 2.810880 1.673800000 2.742736 1.681500000 2.675361 1.689300000 2.608778 1.697100000 2.543832 1.705000000 2.479680 1.713000000 2.416345 1.721000000 2.354606 1.729100000 2.293680 1.737200000 2.234310 1.745400000 2.175749 1.753700000 2.118015 1.762100000 2.061121 1.770500000 2.005733 1.779000000 1.951176 1.787600000 1.897463 1.796300000 1.844606 1.805100000 1.792613 1.814000000 1.741493 1.822900000 1.691805 1.831900000 1.642974 1.841000000 1.595006 1.850200000 1.547906 1.859500000 1.501679 1.868900000 1.456329 1.878300000 1.412319 1.887900000 1.368715 1.897500000 1.326427 1.907200000 1.284994 1.917100000 1.244009 1.927000000 1.204298 1.937100000 1.165058 1.947300000 1.126692 1.957600000 1.089197 1.968000000 1.052568 1.978600000 1.016465 1.989200000 0.981563 2.000000000 0.947196 ]
alter @vmm[pwl] = [ 0.000100000 -15.052534 1.143200000 -15.052534 1.143300000 -15.050738 1.143400000 -15.046310 1.148700000 -14.793144 1.153800000 -14.553420 1.157800000 -14.368113 1.161900000 -14.180611 1.166300000 -13.982100 1.170800000 -13.781940 1.175200000 -13.588988 1.179700000 -13.394432 1.184300000 -13.198420 1.188900000 -13.005264 1.193500000 -12.814922 1.198200000 -12.623306 1.202900000 -12.434543 1.207600000 -12.248590 1.212300000 -12.065405 1.217000000 -11.884946 1.221800000 -11.703421 1.226600000 -11.524654 1.231400000 -11.348605 1.236300000 -11.171648 1.241200000 -10.997436 1.246100000 -10.825927 1.251000000 -10.657078 1.256000000 -10.487484 1.261000000 -10.320574 1.266000000 -10.156306 1.271000000 -9.994638 1.276100000 -9.832373 1.281200000 -9.672727 1.286300000 -9.515658 1.291400000 -9.361124 1.296600000 -9.206128 1.301800000 -9.053683 1.307000000 -8.903747 1.312300000 -8.753466 1.317600000 -8.605705 1.322900000 -8.460422 1.328300000 -8.314903 1.333700000 -8.171871 1.339100000 -8.031281 1.344500000 -7.893094 1.350000000 -7.754774 1.355500000 -7.618860 1.361100000 -7.482905 1.366700000 -7.349357 1.372300000 -7.218174 1.377900000 -7.089315 1.383600000 -6.960498 1.389300000 -6.834003 1.395100000 -6.707629 1.400900000 -6.583572 1.406700000 -6.461790 1.412500000 -6.342241 1.418400000 -6.222879 1.424300000 -6.105744 1.430300000 -5.988864 1.436300000 -5.874201 1.442400000 -5.759855 1.448500000 -5.647713 1.454600000 -5.537733 1.460800000 -5.428123 1.467000000 -5.320659 1.473200000 -5.215301 1.479500000 -5.110357 1.485800000 -5.007502 1.492100000 -4.906694 1.498400000 -4.807892 1.504800000 -4.709536 1.511300000 -4.611677 1.517800000 -4.515827 1.524300000 -4.421945 1.530900000 -4.328590 1.537500000 -4.237180 1.544200000 -4.146334 1.550900000 -4.057409 1.557700000 -3.969080 1.564500000 -3.882648 1.571400000 -3.796840 1.578300000 -3.712901 1.585300000 -3.629613 1.592300000 -3.548165 1.599400000 -3.467391 1.606500000 -3.388426 1.613700000 -3.310156 1.620900000 -3.233663 1.628200000 -3.157881 1.635600000 -3.082842 1.643000000 -3.009554 1.650500000 -2.937021 1.658000000 -2.866202 1.665600000 -2.796148 1.673200000 -2.727773 1.680900000 -2.660168 1.688700000 -2.593358 1.696600000 -2.527365 1.704500000 -2.463015 1.712500000 -2.399482 1.720500000 -2.337551 1.728600000 -2.276437 1.736700000 -2.216881 1.745000000 -2.157431 1.753300000 -2.099535 1.761700000 -2.042481 1.770100000 -1.986937 1.778600000 -1.932227 1.787200000 -1.878363 1.795900000 -1.825356 1.804700000 -1.773216 1.813600000 -1.721953 1.822500000 -1.672124 1.831600000 -1.622619 1.840700000 -1.574531 1.849900000 -1.527313 1.859200000 -1.480970 1.868600000 -1.435507 1.878100000 -1.390924 1.887700000 -1.347225 1.897300000 -1.304844 1.907100000 -1.262899 1.917000000 -1.221838 1.927000000 -1.181658 1.937100000 -1.142357 1.947300000 -1.103932 1.957600000 -1.066379 1.968000000 -1.029694 1.978600000 -0.993535 1.989200000 -0.958580 2.000000000 -0.924160 ]
alter @vpwl[pwl] = [ 0 1 1000 1 ]
alter @vis[pwl] = [ 0.000100000 1.167331e-02 1.012400000 1.167331e-02 1.012500000 1.157497e-02 1.012800000 9.601875e-03 1.013200000 7.444265e-03 1.013500000 6.132644e-03 1.013800000 5.044129e-03 1.014200000 3.882358e-03 1.014600000 2.988104e-03 1.015000000 2.302665e-03 1.015200000 2.022958e-03 1.015500000 1.667895e-03 1.015700000 1.467939e-03 1.016000000 1.214000e-03 1.016300000 1.006086e-03 1.016600000 8.356733e-04 1.016900000 6.957659e-04 1.017200000 5.806992e-04 1.017600000 4.581001e-04 1.018000000 3.630272e-04 1.018400000 2.890064e-04 1.018600000 2.583091e-04 1.018900000 2.187369e-04 1.019400000 1.667396e-04 1.019700000 1.421625e-04 1.020000000 1.215148e-04 1.020300000 1.041252e-04 1.020700000 8.507345e-05 1.021000000 7.331757e-05 1.021400000 6.035474e-05 1.021800000 4.989284e-05 1.022200000 4.141454e-05 1.022700000 3.299950e-05 1.023200000 2.645672e-05 1.023600000 2.226545e-05 1.024100000 1.804250e-05 1.024600000 1.470427e-05 1.025100000 1.205056e-05 1.025700000 9.558392e-06 1.026400000 7.364276e-06 1.026800000 6.373154e-06 1.027200000 5.532913e-06 1.027600000 4.818313e-06 1.028000000 4.208731e-06 1.028400000 3.687177e-06 1.028900000 3.137904e-06 1.029400000 2.682254e-06 1.029900000 2.302613e-06 1.030500000 1.927881e-06 1.031100000 1.623544e-06 1.031700000 1.374974e-06 1.032400000 1.140476e-06 1.033200000 9.291191e-07 1.034000000 7.637311e-07 1.034900000 6.188794e-07 1.036000000 4.853397e-07 1.037100000 3.861922e-07 1.037700000 3.429293e-07 1.038400000 3.000342e-07 1.039100000 2.638680e-07 1.039900000 2.292357e-07 1.040700000 2.003968e-07 1.041600000 1.735001e-07 1.042900000 1.426866e-07 1.044300000 1.174197e-07 1.045900000 9.572052e-08 1.047700000 7.771854e-08 1.049700000 6.316928e-08 1.052100000 5.075852e-08 1.054900000 4.077263e-08 1.058100000 3.305696e-08 1.061400000 2.765341e-08 1.065200000 2.340846e-08 1.069800000 1.999562e-08 1.075300000 1.737879e-08 1.081700000 1.548123e-08 1.089600000 1.408042e-08 1.099400000 1.310983e-08 1.112000000 1.247934e-08 1.114800000 1.084904e-08 1.118000000 9.497340e-09 1.125900000 7.502124e-09 1.136200000 6.072613e-09 1.146500000 5.182668e-09 1.161200000 4.435584e-09 1.181800000 3.782892e-09 1.418000000 2.624707e-09 1.775400000 1.245435e-09 1.821300000 2.253897e-09 1.931500000 4.074252e-09 2.000000000 5.797536e-09 ]
alter @vip[pwl] = [ 0.000100000 1.188839e-08 1.012400000 1.188839e-08 1.012500000 1.201568e-08 1.012800000 1.464424e-08 1.013100000 1.790762e-08 1.013400000 2.194426e-08 1.013700000 2.691684e-08 1.013900000 3.084773e-08 1.014300000 4.048618e-08 1.014600000 4.958154e-08 1.014800000 5.670539e-08 1.015100000 6.924872e-08 1.015300000 7.902628e-08 1.015600000 9.615958e-08 1.015800000 1.094532e-07 1.016200000 1.413291e-07 1.016600000 1.816413e-07 1.016900000 2.185675e-07 1.017300000 2.785474e-07 1.017600000 3.330347e-07 1.017900000 3.970863e-07 1.018200000 4.721606e-07 1.018700000 6.263335e-07 1.019200000 8.246725e-07 1.019700000 1.077893e-06 1.020200000 1.398794e-06 1.020600000 1.714348e-06 1.021000000 2.091856e-06 1.021400000 2.541485e-06 1.021800000 3.074727e-06 1.022100000 3.537221e-06 1.022500000 4.248688e-06 1.022800000 4.861924e-06 1.023200000 5.799480e-06 1.023500000 6.602703e-06 1.024100000 8.504121e-06 1.024700000 1.086302e-05 1.025300000 1.376575e-05 1.025800000 1.666999e-05 1.026300000 2.008159e-05 1.026800000 2.406863e-05 1.027300000 2.870471e-05 1.028000000 3.643733e-05 1.028700000 4.583381e-05 1.029400000 5.715017e-05 1.030000000 6.858569e-05 1.030600000 8.181691e-05 1.031200000 9.703402e-05 1.031800000 1.144347e-04 1.032400000 1.342213e-04 1.033500000 1.773752e-04 1.034500000 2.252299e-04 1.035500000 2.822587e-04 1.036500000 3.493413e-04 1.037500000 4.272794e-04 1.038400000 5.072834e-04 1.040300000 7.086842e-04 1.042200000 9.560253e-04 1.044100000 1.249610e-03 1.047200000 1.822032e-03 1.050500000 2.538302e-03 1.062800000 5.577934e-03 1.068600000 6.888716e-03 1.074800000 8.067498e-03 1.081200000 9.029950e-03 1.087800000 9.780304e-03 1.094900000 1.036544e-02 1.112000000 1.115020e-02 1.112300000 9.267878e-03 1.112600000 7.658042e-03 1.112900000 6.310206e-03 1.113300000 4.860198e-03 1.113600000 3.990718e-03 1.114000000 3.066981e-03 1.114400000 2.358522e-03 1.114600000 2.069422e-03 1.114900000 1.702550e-03 1.115100000 1.496058e-03 1.115400000 1.234021e-03 1.115600000 1.086454e-03 1.115900000 8.989970e-04 1.116200000 7.454391e-04 1.116500000 6.194681e-04 1.116900000 4.856972e-04 1.117300000 3.824018e-04 1.117700000 3.023543e-04 1.117900000 2.692841e-04 1.118200000 2.267913e-04 1.118400000 2.025284e-04 1.118700000 1.712568e-04 1.118900000 1.533447e-04 1.119200000 1.301865e-04 1.119500000 1.107887e-04 1.119800000 9.450372e-05 1.120100000 8.080053e-05 1.120500000 6.580642e-05 1.120900000 5.381156e-05 1.121300000 4.417943e-05 1.121800000 3.471654e-05 1.122300000 2.744439e-05 1.122700000 2.283602e-05 1.123100000 1.907144e-05 1.123600000 1.530327e-05 1.124100000 1.234749e-05 1.124700000 9.611708e-06 1.125300000 7.538441e-06 1.125600000 6.694441e-06 1.126000000 5.730180e-06 1.126700000 4.397597e-06 1.127100000 3.796126e-06 1.127500000 3.286639e-06 1.127900000 2.853805e-06 1.128400000 2.401598e-06 1.128900000 2.029837e-06 1.129400000 1.722903e-06 1.130000000 1.422929e-06 1.130600000 1.182003e-06 1.131300000 9.557301e-07 1.132000000 7.773690e-07 1.132800000 6.192939e-07 1.133700000 4.847069e-07 1.134700000 3.739175e-07 1.135300000 3.219910e-07 1.135900000 2.785229e-07 1.136500000 2.419770e-07 1.137200000 2.064580e-07 1.137900000 1.771409e-07 1.138700000 1.496858e-07 1.139500000 1.273517e-07 1.140400000 1.070202e-07 1.141400000 8.904248e-08 1.142500000 7.352988e-08 1.143700000 6.041417e-08 1.145000000 4.950900e-08 1.146500000 4.001249e-08 1.148200000 3.207365e-08 1.150000000 2.593159e-08 1.152100000 2.076045e-08 1.154500000 1.659587e-08 1.157300000 1.324695e-08 1.160500000 1.066026e-08 1.164400000 8.581534e-09 1.169100000 6.979786e-09 1.174900000 5.745416e-09 1.181700000 4.860719e-09 1.194200000 4.181299e-09 1.211100000 3.769501e-09 1.236800000 3.492296e-09 1.775500000 1.245302e-09 1.821200000 2.252084e-09 1.931600000 4.076278e-09 2.000000000 5.797536e-09 ]
tran 1e-05 2.000000000002 0 1e-05
wrdata guasto_u503_min_l41c$d v(mainjack) v(fixjack1) v(fixjack2)
wrdata guasto_u503_min_l41c_stati$d v(xls.xs) v(xlp.xs) v(dep) v(ina) v(vplus) v(vminus) v(main_a) v(mainc) v(fixc1) v(fixc2)
destroy all
echo "guasto_u503_min_l41c,guasto_u503_min_l41c.dat,l41c_guasto_u503_min,1000,0,10a0,100k,0.990000000,1000,2.000000000002,1e-05,evento,rif_guasto_u503_min_l41c,-,0.0,6,A_ins" >> tb_v2_casopeggiore_manifest.csv
* ---- L41c: rif_cf_nodelta_l41c (dal ponte: cf_nodelta, giro 3) ----
alter vamp dc = 0
alter vfrq dc = 1000
alter rldm = 100k
alter rld1 = 100k
alter rld2 = 100k
alter vti dc = 1000
alter vtr dc = 2000
alter vtijk dc = 1000
alter vtrjk dc = 1000
alter vosa dc = 0
alter vosb dc = 0
alter vosf1 dc = 0
alter vosf2 dc = 0
alter ratth = 1m
alter rattb = 10k
alter rl1 = 845
alter cwire = 100p
alter vk1bi dc = 1
alter vk1bt dc = 1000.000000
alter vk5bi dc = 1
alter vk5bt dc = 1000.000000
alter vk1i dc = 0
alter vk1t dc = 1000.000000
alter vk5i dc = 0
alter vk5t dc = 1000.000000
alter vt1ri dc = 1
alter vt1rt dc = 1000.000000
alter vt1si dc = 0
alter vt1st dc = 1000.000000
alter vt2ri dc = 1
alter vt2rt dc = 1000.000000
alter vt2si dc = 0
alter vt2st dc = 1000.000000
alter vtijk dc = 1000.000000
alter vtrjk dc = 2000.000000
alter vksa dc = 1000.000000
alter vksb dc = 1000.001000
alter vkca dc = 1000.001000
alter vkcb dc = 1000.000000
alter vtiser dc = -10
alter vtrser dc = 1000
alter rbym = 1e12
alter rby1 = 1e12
alter rby2 = 1e12
alter rbcm = 220k
alter rbc1 = 470k
alter rbc2 = 470k
alter cksm = 0.1p
alter cks1 = 0.1p
alter cks2 = 0.1p
alter ccavm = 1e-18
alter ccav1 = 1e-18
alter ccav2 = 1e-18
print @cksm[capacitance] @cks1[capacitance] @cks2[capacitance] @ccavm[capacitance] @ccav1[capacitance] @ccav2[capacitance]
alter @vpp[pwl] = [ 0.000100000 14.999735 0.990000000 14.999735 2.000000000 14.999735 ]
alter @vmm[pwl] = [ 0.000100000 -15.052534 0.990000000 -15.052534 2.000000000 -15.052534 ]
alter @vpwl[pwl] = [ 0 1 1000 1 ]
alter @vis[pwl] = [ 0.000100000 1.201624e-02 0.990000000 1.201626e-02 2.000000000 1.201626e-02 ]
alter @vip[pwl] = [ 0.000100000 1.226115e-08 0.990000000 1.226117e-08 2.000000000 1.226117e-08 ]
tran 1e-05 2.000000000002 0 1e-05
wrdata rif_cf_nodelta_l41c$d v(mainjack) v(fixjack1) v(fixjack2)
wrdata rif_cf_nodelta_l41c_stati$d v(xls.xs) v(xlp.xs) v(dep) v(ina) v(vplus) v(vminus) v(main_a) v(mainc) v(fixc1) v(fixc2)
destroy all
echo "rif_cf_nodelta_l41c,rif_cf_nodelta_l41c.dat,rif,1000,0,10,100k,0.990000000,1000,2.000000000002,1e-05,rif_mai,-,-,0.0,0," >> tb_v2_casopeggiore_manifest.csv
* ---- L41c: cf_nodelta_l41c (dal ponte: cf_nodelta, giro 3) ----
alter vamp dc = 0
alter vfrq dc = 1000
alter rldm = 100k
alter rld1 = 100k
alter rld2 = 100k
alter vti dc = 1000
alter vtr dc = 2000
alter vtijk dc = 1.0174000000000003
alter vtrjk dc = 1000
alter vosa dc = 0
alter vosb dc = 0
alter vosf1 dc = 0
alter vosf2 dc = 0
alter ratth = 1m
alter rattb = 10k
alter rl1 = 845
alter cwire = 100p
alter vk1bi dc = 1
alter vk1bt dc = 1.014400
alter vk5bi dc = 1
alter vk5bt dc = 1.014700
alter vk1i dc = 0
alter vk1t dc = 1000.000000
alter vk5i dc = 0
alter vk5t dc = 1000.000000
alter vt1ri dc = 1
alter vt1rt dc = 1000.000000
alter vt1si dc = 0
alter vt1st dc = 1000.000000
alter vt2ri dc = 1
alter vt2rt dc = 1000.000000
alter vt2si dc = 0
alter vt2st dc = 1000.000000
alter vtijk dc = 1000.000000
alter vtrjk dc = 2000.000000
alter vksa dc = 1.017400
alter vksb dc = 1000.001000
alter vkca dc = 1.018400
alter vkcb dc = 1000.000000
alter vtiser dc = -10
alter vtrser dc = 1000
alter rbym = 1e12
alter rby1 = 1e12
alter rby2 = 1e12
alter rbcm = 220k
alter rbc1 = 470k
alter rbc2 = 470k
alter cksm = 0.1p
alter cks1 = 0.1p
alter cks2 = 0.1p
alter ccavm = 1e-18
alter ccav1 = 1e-18
alter ccav2 = 1e-18
print @cksm[capacitance] @cks1[capacitance] @cks2[capacitance] @ccavm[capacitance] @ccav1[capacitance] @ccav2[capacitance]
alter @vpp[pwl] = [ 0.000100000 14.999735 1.074400000 14.999735 1.074500000 14.997381 1.074600000 14.992913 1.079900000 14.740998 1.082500000 14.618915 1.085100000 14.497841 1.089400000 14.299795 1.093800000 14.099938 1.098500000 13.889530 1.103200000 13.682256 1.107900000 13.478067 1.112600000 13.276918 1.117400000 13.074580 1.122200000 12.875319 1.127100000 12.675030 1.132000000 12.477848 1.136900000 12.283727 1.141800000 12.092617 1.146800000 11.900664 1.151800000 11.711749 1.156800000 11.525825 1.161900000 11.339215 1.167000000 11.155617 1.172100000 10.974984 1.177200000 10.797266 1.182400000 10.619018 1.187600000 10.443704 1.192900000 10.267987 1.198200000 10.095217 1.203500000 9.925345 1.208800000 9.758322 1.214200000 9.591029 1.219600000 9.426594 1.225000000 9.264968 1.230400000 9.106105 1.235900000 8.947089 1.241400000 8.790840 1.246900000 8.637310 1.252500000 8.483733 1.258100000 8.332876 1.263700000 8.184691 1.269400000 8.036556 1.275100000 7.891090 1.280900000 7.745765 1.286700000 7.603104 1.292500000 7.463060 1.298400000 7.323237 1.304300000 7.186021 1.310200000 7.051366 1.316200000 6.917003 1.322200000 6.785189 1.328200000 6.655875 1.334300000 6.526920 1.340400000 6.400451 1.346600000 6.274407 1.352800000 6.150833 1.359000000 6.029680 1.365300000 5.909004 1.371600000 5.790730 1.378000000 5.672989 1.384400000 5.557628 1.390900000 5.442852 1.397400000 5.330433 1.403900000 5.220321 1.410500000 5.110829 1.417200000 5.002011 1.423900000 4.895496 1.430600000 4.791234 1.437300000 4.689178 1.444100000 4.587806 1.450900000 4.488610 1.457700000 4.391544 1.464600000 4.295180 1.471600000 4.199564 1.478600000 4.106061 1.485700000 4.013332 1.492800000 3.922680 1.500000000 3.832825 1.507200000 3.745012 1.514500000 3.658015 1.521800000 3.573022 1.529200000 3.488862 1.536700000 3.405568 1.544200000 3.324245 1.551800000 3.243799 1.559400000 3.165281 1.567100000 3.087648 1.574800000 3.011900 1.582600000 2.937043 1.590500000 2.863102 1.598500000 2.790101 1.606500000 2.718940 1.614600000 2.648717 1.622800000 2.579452 1.631000000 2.511976 1.639300000 2.445453 1.647700000 2.379898 1.656100000 2.316077 1.664700000 2.252485 1.673300000 2.190615 1.682000000 2.129730 1.690700000 2.070511 1.699600000 2.011610 1.708500000 1.954357 1.717500000 1.898092 1.726600000 1.842821 1.735800000 1.788551 1.745000000 1.735851 1.754400000 1.683580 1.763800000 1.632854 1.773400000 1.582596 1.783000000 1.533854 1.792700000 1.486098 1.802600000 1.438858 1.812500000 1.393087 1.822600000 1.347859 1.832700000 1.304065 1.843000000 1.260834 1.853400000 1.218602 1.863900000 1.177362 1.874500000 1.137107 1.885300000 1.097471 1.896100000 1.059177 1.907100000 1.021507 1.918200000 0.984812 1.929500000 0.948767 1.940900000 0.913697 1.952400000 0.879589 1.964100000 0.846149 1.975900000 0.813664 1.987900000 0.781860 2.000000000 0.751000 ]
alter @vmm[pwl] = [ 0.000100000 -15.052534 1.073200000 -15.052534 1.073300000 -15.050822 1.073400000 -15.046405 1.076300000 -14.907410 1.078900000 -14.783766 1.081500000 -14.661144 1.084200000 -14.534879 1.088500000 -14.336021 1.092800000 -14.139873 1.097400000 -13.932998 1.102100000 -13.724740 1.106800000 -13.519581 1.111500000 -13.317477 1.116300000 -13.114177 1.121100000 -12.913967 1.126000000 -12.712725 1.130900000 -12.514605 1.135800000 -12.319558 1.140800000 -12.123650 1.145800000 -11.930843 1.150800000 -11.741087 1.155800000 -11.554335 1.160900000 -11.366893 1.166000000 -11.182476 1.171100000 -11.001037 1.176200000 -10.822526 1.181400000 -10.643482 1.186600000 -10.467384 1.191900000 -10.290881 1.197200000 -10.117338 1.202500000 -9.946705 1.207800000 -9.778934 1.213200000 -9.610890 1.218600000 -9.445718 1.224000000 -9.283367 1.229400000 -9.123789 1.234900000 -8.964059 1.240400000 -8.807107 1.246000000 -8.650107 1.251600000 -8.495887 1.257200000 -8.344399 1.262800000 -8.195594 1.268500000 -8.046837 1.274200000 -7.900762 1.280000000 -7.754826 1.285800000 -7.611566 1.291600000 -7.470934 1.297500000 -7.330522 1.303400000 -7.192729 1.309300000 -7.057506 1.315300000 -6.922577 1.321300000 -6.790207 1.327300000 -6.660347 1.333400000 -6.530847 1.339500000 -6.403844 1.345700000 -6.277266 1.351900000 -6.153169 1.358200000 -6.029559 1.364500000 -5.908410 1.370800000 -5.789672 1.377200000 -5.671469 1.383600000 -5.555655 1.390100000 -5.440427 1.396600000 -5.327565 1.403100000 -5.217020 1.409700000 -5.107095 1.416400000 -4.997848 1.423100000 -4.890912 1.429800000 -4.786238 1.436500000 -4.683778 1.443300000 -4.582004 1.450100000 -4.482415 1.456900000 -4.384964 1.463800000 -4.288218 1.470800000 -4.192222 1.477800000 -4.098346 1.484900000 -4.005247 1.492000000 -3.914234 1.499200000 -3.824021 1.506400000 -3.735857 1.513700000 -3.648512 1.521100000 -3.562024 1.528500000 -3.477554 1.536000000 -3.393953 1.543500000 -3.312329 1.551100000 -3.231586 1.558700000 -3.152778 1.566400000 -3.074858 1.574200000 -2.997853 1.582000000 -2.922742 1.589900000 -2.848550 1.597900000 -2.775301 1.605900000 -2.703897 1.614000000 -2.633435 1.622200000 -2.563934 1.630500000 -2.495413 1.638800000 -2.428683 1.647200000 -2.362924 1.655600000 -2.298905 1.664200000 -2.235115 1.672800000 -2.173052 1.681500000 -2.111977 1.690200000 -2.052575 1.699100000 -1.993490 1.708000000 -1.936060 1.717000000 -1.879620 1.726100000 -1.824178 1.735300000 -1.769740 1.744600000 -1.716310 1.754000000 -1.663895 1.763400000 -1.613028 1.773000000 -1.562630 1.782600000 -1.513754 1.792300000 -1.465866 1.802200000 -1.418495 1.812200000 -1.372142 1.822300000 -1.326804 1.832500000 -1.282475 1.842800000 -1.239153 1.853200000 -1.196832 1.863700000 -1.155505 1.874300000 -1.115167 1.885100000 -1.075447 1.896000000 -1.036723 1.907000000 -0.998987 1.918100000 -0.962227 1.929400000 -0.926119 1.940800000 -0.890987 1.952400000 -0.856527 1.964100000 -0.823039 1.975900000 -0.790508 1.987900000 -0.758658 2.000000000 -0.727755 ]
alter @vpwl[pwl] = [ 0 1 1000 1 ]
alter @vis[pwl] = [ 0.000100000 1.201624e-02 1.014300000 1.201626e-02 1.014400000 1.159833e-02 1.014700000 9.626475e-03 1.015000000 7.961875e-03 1.015300000 6.567522e-03 1.015600000 5.407266e-03 1.016000000 4.165983e-03 1.016400000 3.208402e-03 1.016800000 2.473227e-03 1.017000000 2.172949e-03 1.017300000 1.791569e-03 1.017500000 1.576703e-03 1.017800000 1.303756e-03 1.018100000 1.080254e-03 1.018400000 8.970339e-04 1.018700000 7.466166e-04 1.019000000 6.229199e-04 1.019400000 4.911571e-04 1.019800000 3.890123e-04 1.020200000 3.095177e-04 1.020400000 2.765616e-04 1.020700000 2.340902e-04 1.021200000 1.783109e-04 1.021500000 1.519602e-04 1.021800000 1.298309e-04 1.022100000 1.112019e-04 1.022500000 9.080168e-05 1.022800000 7.821973e-05 1.023200000 6.435310e-05 1.023600000 5.316769e-05 1.024000000 4.410804e-05 1.024500000 3.512144e-05 1.025000000 2.813876e-05 1.025400000 2.366867e-05 1.025900000 1.916711e-05 1.026400000 1.561095e-05 1.026900000 1.278575e-05 1.027500000 1.013427e-05 1.028100000 8.093727e-06 1.028500000 6.995656e-06 1.028900000 6.065873e-06 1.029300000 5.276105e-06 1.029700000 4.603197e-06 1.030100000 4.028127e-06 1.030600000 3.423259e-06 1.031100000 2.922179e-06 1.031600000 2.505259e-06 1.032200000 2.094290e-06 1.032800000 1.761041e-06 1.033400000 1.489255e-06 1.034100000 1.233242e-06 1.034900000 1.002883e-06 1.035700000 8.229387e-07 1.036600000 6.656166e-07 1.037700000 5.208638e-07 1.038800000 4.136118e-07 1.039400000 3.668840e-07 1.040100000 3.206043e-07 1.040800000 2.816290e-07 1.041600000 2.443504e-07 1.042400000 2.133447e-07 1.043300000 1.844626e-07 1.044300000 1.582748e-07 1.045400000 1.350594e-07 1.046600000 1.148604e-07 1.048000000 9.638396e-08 1.049500000 8.108860e-08 1.051100000 6.851730e-08 1.052900000 5.771102e-08 1.055000000 4.826894e-08 1.057300000 4.064331e-08 1.059900000 3.434875e-08 1.062900000 2.913546e-08 1.066300000 2.496505e-08 1.070300000 2.156912e-08 1.075000000 1.887915e-08 1.080600000 1.678274e-08 1.087400000 1.518397e-08 1.095700000 1.402212e-08 1.106100000 1.321767e-08 1.137200000 1.242631e-08 1.404100000 1.226082e-08 1.465200000 8.993401e-09 1.533500000 6.069457e-09 1.604100000 3.692782e-09 1.657800000 2.309815e-09 1.667800000 2.204336e-09 1.671200000 3.017352e-09 1.674200000 4.035212e-09 1.677000000 5.330525e-09 1.679500000 6.859172e-09 1.681900000 8.745140e-09 1.684200000 1.100432e-08 1.689300000 1.743561e-08 1.708400000 2.815386e-08 1.727400000 4.041853e-08 1.744300000 5.292986e-08 1.760100000 6.637349e-08 1.777100000 8.313213e-08 1.793200000 1.015702e-07 1.832100000 1.549325e-07 1.843100000 1.620105e-07 1.849200000 1.594545e-07 1.855800000 1.516801e-07 1.883600000 9.874198e-08 1.893600000 8.129315e-08 1.906800000 6.215271e-08 1.920700000 4.653564e-08 1.928500000 3.952140e-08 1.936800000 3.321695e-08 1.945600000 2.764408e-08 1.954900000 2.279269e-08 1.964900000 1.855219e-08 1.975600000 1.491733e-08 1.987300000 1.178652e-08 2.000000000 9.160670e-09 ]
alter @vip[pwl] = [ 0.000100000 1.226115e-08 1.014300000 1.226117e-08 1.014400000 1.275729e-08 1.014700000 1.557425e-08 1.015100000 2.041064e-08 1.015500000 2.681513e-08 1.015900000 3.523906e-08 1.016200000 4.321671e-08 1.016400000 4.948077e-08 1.016700000 6.053797e-08 1.016900000 6.917803e-08 1.017300000 9.007547e-08 1.017700000 1.167945e-07 1.018100000 1.507566e-07 1.018400000 1.820013e-07 1.018800000 2.329727e-07 1.019100000 2.794706e-07 1.019400000 3.343247e-07 1.019700000 3.988432e-07 1.020200000 5.319539e-07 1.020700000 7.041506e-07 1.021200000 9.251859e-07 1.021700000 1.206774e-06 1.022100000 1.484941e-06 1.022500000 1.819055e-06 1.022900000 2.218568e-06 1.023300000 2.694187e-06 1.023600000 3.108051e-06 1.024000000 3.746775e-06 1.024300000 4.299044e-06 1.024700000 5.146003e-06 1.025000000 5.873851e-06 1.025600000 7.603484e-06 1.026200000 9.759933e-06 1.026700000 1.194263e-05 1.027200000 1.453318e-05 1.027700000 1.759108e-05 1.028200000 2.118154e-05 1.028700000 2.537560e-05 1.029500000 3.353572e-05 1.030200000 4.237748e-05 1.030900000 5.307384e-05 1.031600000 6.590022e-05 1.032200000 7.881200e-05 1.032800000 9.369912e-05 1.033400000 1.107636e-04 1.034000000 1.302130e-04 1.035100000 1.727683e-04 1.036200000 2.253649e-04 1.037200000 2.829795e-04 1.038200000 3.508784e-04 1.039200000 4.299035e-04 1.040200000 5.207912e-04 1.042100000 7.282096e-04 1.044000000 9.831117e-04 1.045900000 1.285823e-03 1.049000000 1.876293e-03 1.052300000 2.615305e-03 1.064400000 5.699938e-03 1.069900000 6.990682e-03 1.075700000 8.151984e-03 1.081600000 9.107068e-03 1.093200000 1.040337e-02 1.106900000 1.123670e-02 1.125000000 1.172460e-02 1.151500000 1.194815e-02 1.315200000 1.201597e-02 1.404200000 1.201258e-02 1.480500000 8.635797e-03 1.572600000 4.968508e-03 1.583100000 4.325237e-03 1.604800000 2.410837e-03 1.611100000 1.927456e-03 1.617300000 1.521206e-03 1.624500000 1.136037e-03 1.628200000 9.719379e-04 1.632100000 8.215374e-04 1.636100000 6.891251e-04 1.640200000 5.738613e-04 1.644500000 4.724517e-04 1.649100000 3.829144e-04 1.654200000 3.028210e-04 1.659700000 2.348614e-04 1.664600000 1.872332e-04 1.674500000 1.067499e-04 1.677200000 8.802722e-05 1.679600000 7.368346e-05 1.682100000 6.138083e-05 1.684700000 5.122952e-05 1.686800000 4.462001e-05 1.689000000 3.895973e-05 1.692900000 3.328859e-05 1.697300000 2.800595e-05 1.702800000 2.265343e-05 1.708800000 1.805391e-05 1.715400000 1.413574e-05 1.722600000 1.088633e-05 1.726500000 9.472930e-06 1.730700000 8.170501e-06 1.735100000 7.011947e-06 1.739700000 5.989111e-06 1.744600000 5.075440e-06 1.749900000 4.255183e-06 1.755600000 3.531437e-06 1.761700000 2.902934e-06 1.767500000 2.417385e-06 1.773700000 1.994723e-06 1.780500000 1.622138e-06 1.787800000 1.305150e-06 1.795800000 1.033803e-06 1.804600000 8.048428e-07 1.809400000 7.039099e-07 1.814400000 6.133430e-07 1.819700000 5.310939e-07 1.825300000 4.571319e-07 1.830900000 3.943174e-07 1.836900000 3.373364e-07 1.843200000 2.870506e-07 1.850000000 2.418036e-07 1.857300000 2.017344e-07 1.865100000 1.667658e-07 1.873500000 1.363323e-07 1.882700000 1.097631e-07 1.892400000 8.769868e-08 1.903100000 6.878050e-08 1.914900000 5.288300e-08 1.928000000 3.972877e-08 1.935100000 3.410463e-08 1.942600000 2.907556e-08 1.950600000 2.457134e-08 1.959100000 2.058901e-08 1.968200000 1.707596e-08 1.978000000 1.399480e-08 1.988500000 1.133956e-08 2.000000000 9.035654e-09 ]
tran 1e-05 2.000000000002 0 1e-05
wrdata cf_nodelta_l41c$d v(mainjack) v(fixjack1) v(fixjack2)
wrdata cf_nodelta_l41c_stati$d v(xls.xs) v(xlp.xs) v(dep) v(ina) v(vplus) v(vminus) v(main_a) v(mainc) v(fixc1) v(fixc2)
destroy all
echo "cf_nodelta_l41c,cf_nodelta_l41c.dat,l41c_cf_nodelta,1000,0,10a0,100k,0.990000000,1000,2.000000000002,1e-05,evento,rif_cf_nodelta_l41c,-,0.0,6,A_ins" >> tb_v2_casopeggiore_manifest.csv
* ---- L41c: rif_corto_u503_l41c (dal ponte: corto_u503, giro 2) ----
alter vamp dc = 0
alter vfrq dc = 1000
alter rldm = 100k
alter rld1 = 100k
alter rld2 = 100k
alter vti dc = 1000
alter vtr dc = 2000
alter vtijk dc = 1000
alter vtrjk dc = 1000
alter vosa dc = 0
alter vosb dc = 0
alter vosf1 dc = 0
alter vosf2 dc = 0
alter ratth = 1m
alter rattb = 10k
alter rl1 = 845
alter cwire = 100p
alter vk1bi dc = 1
alter vk1bt dc = 1000.000000
alter vk5bi dc = 1
alter vk5bt dc = 1000.000000
alter vk1i dc = 0
alter vk1t dc = 1000.000000
alter vk5i dc = 0
alter vk5t dc = 1000.000000
alter vt1ri dc = 1
alter vt1rt dc = 1000.000000
alter vt1si dc = 0
alter vt1st dc = 1000.000000
alter vt2ri dc = 1
alter vt2rt dc = 1000.000000
alter vt2si dc = 0
alter vt2st dc = 1000.000000
alter vtijk dc = 1000.000000
alter vtrjk dc = 2000.000000
alter vksa dc = 1000.000000
alter vksb dc = 1000.001000
alter vkca dc = 1000.001000
alter vkcb dc = 1000.000000
alter vtiser dc = -10
alter vtrser dc = 1000
alter rbym = 1e12
alter rby1 = 1e12
alter rby2 = 1e12
alter rbcm = 220k
alter rbc1 = 470k
alter rbc2 = 470k
alter cksm = 0.1p
alter cks1 = 0.1p
alter cks2 = 0.1p
alter ccavm = 1e-18
alter ccav1 = 1e-18
alter ccav2 = 1e-18
print @cksm[capacitance] @cks1[capacitance] @cks2[capacitance] @ccavm[capacitance] @ccav1[capacitance] @ccav2[capacitance]
alter @vpp[pwl] = [ 0.000100000 14.999735 0.990000000 14.999735 2.000000000 14.999735 ]
alter @vmm[pwl] = [ 0.000100000 -15.052534 0.990000000 -15.052534 2.000000000 -15.052534 ]
alter @vpwl[pwl] = [ 0 1 1000 1 ]
alter @vis[pwl] = [ 0.000100000 1.201624e-02 0.990000000 1.201624e-02 2.000000000 1.201624e-02 ]
alter @vip[pwl] = [ 0.000100000 1.226115e-08 0.990000000 1.226115e-08 2.000000000 1.226115e-08 ]
tran 1e-05 2.000000000002 0 1e-05
wrdata rif_corto_u503_l41c$d v(mainjack) v(fixjack1) v(fixjack2)
wrdata rif_corto_u503_l41c_stati$d v(xls.xs) v(xlp.xs) v(dep) v(ina) v(vplus) v(vminus) v(main_a) v(mainc) v(fixc1) v(fixc2)
destroy all
echo "rif_corto_u503_l41c,rif_corto_u503_l41c.dat,rif,1000,0,10,100k,0.990000000,1000,2.000000000002,1e-05,rif_mai,-,-,0.0,0," >> tb_v2_casopeggiore_manifest.csv
* ---- L41c: corto_u503_l41c (dal ponte: corto_u503, giro 2) ----
alter vamp dc = 0
alter vfrq dc = 1000
alter rldm = 100k
alter rld1 = 100k
alter rld2 = 100k
alter vti dc = 1000
alter vtr dc = 2000
alter vtijk dc = 1.0031000000000003
alter vtrjk dc = 1000
alter vosa dc = 0
alter vosb dc = 0
alter vosf1 dc = 0
alter vosf2 dc = 0
alter ratth = 1m
alter rattb = 10k
alter rl1 = 845
alter cwire = 100p
alter vk1bi dc = 1
alter vk1bt dc = 1.000100
alter vk5bi dc = 1
alter vk5bt dc = 1.000400
alter vk1i dc = 0
alter vk1t dc = 1000.000000
alter vk5i dc = 0
alter vk5t dc = 1000.000000
alter vt1ri dc = 1
alter vt1rt dc = 1000.000000
alter vt1si dc = 0
alter vt1st dc = 1000.000000
alter vt2ri dc = 1
alter vt2rt dc = 1000.000000
alter vt2si dc = 0
alter vt2st dc = 1000.000000
alter vtijk dc = 1000.000000
alter vtrjk dc = 2000.000000
alter vksa dc = 1.003100
alter vksb dc = 1000.001000
alter vkca dc = 1.004100
alter vkcb dc = 1000.000000
alter vtiser dc = -10
alter vtrser dc = 1000
alter rbym = 1e12
alter rby1 = 1e12
alter rby2 = 1e12
alter rbcm = 220k
alter rbc1 = 470k
alter rbc2 = 470k
alter cksm = 0.1p
alter cks1 = 0.1p
alter cks2 = 0.1p
alter ccavm = 1e-18
alter ccav1 = 1e-18
alter ccav2 = 1e-18
print @cksm[capacitance] @cks1[capacitance] @cks2[capacitance] @ccavm[capacitance] @ccav1[capacitance] @ccav2[capacitance]
alter @vpp[pwl] = [ 0.000100000 14.999735 1.074400000 14.999735 1.074500000 14.997383 1.074600000 14.992913 1.079900000 14.740998 1.082500000 14.618915 1.085100000 14.497841 1.089400000 14.299795 1.093800000 14.099937 1.098500000 13.889530 1.103200000 13.682256 1.107900000 13.478067 1.112600000 13.276918 1.117400000 13.074580 1.122200000 12.875318 1.127100000 12.675029 1.132000000 12.477848 1.136900000 12.283727 1.141800000 12.092617 1.146800000 11.900664 1.151800000 11.711749 1.156800000 11.525825 1.161900000 11.339215 1.167000000 11.155617 1.172100000 10.974983 1.177200000 10.797266 1.182400000 10.619018 1.187600000 10.443703 1.192900000 10.267986 1.198200000 10.095217 1.203500000 9.925345 1.208800000 9.758322 1.214200000 9.591029 1.219600000 9.426594 1.225000000 9.264968 1.230400000 9.106104 1.235900000 8.947089 1.241400000 8.790840 1.246900000 8.637310 1.252500000 8.483732 1.258100000 8.332876 1.263700000 8.184691 1.269400000 8.036555 1.275100000 7.891090 1.280900000 7.745765 1.286700000 7.603104 1.292500000 7.463060 1.298400000 7.323237 1.304300000 7.186021 1.310200000 7.051366 1.316200000 6.917003 1.322200000 6.785189 1.328200000 6.655875 1.334300000 6.526920 1.340400000 6.400451 1.346600000 6.274407 1.352800000 6.150833 1.359000000 6.029680 1.365300000 5.909004 1.371600000 5.790730 1.378000000 5.672989 1.384400000 5.557628 1.390900000 5.442852 1.397400000 5.330433 1.403900000 5.220321 1.410500000 5.110829 1.417200000 5.002011 1.423900000 4.895496 1.430600000 4.791234 1.437300000 4.689178 1.444100000 4.587806 1.450900000 4.488610 1.457700000 4.391544 1.464600000 4.295180 1.471600000 4.199564 1.478600000 4.106061 1.485700000 4.013332 1.492800000 3.922680 1.500000000 3.832825 1.507200000 3.745012 1.514500000 3.658015 1.521800000 3.573022 1.529200000 3.488861 1.536700000 3.405568 1.544200000 3.324245 1.551800000 3.243799 1.559400000 3.165281 1.567100000 3.087648 1.574800000 3.011900 1.582600000 2.937043 1.590500000 2.863102 1.598500000 2.790101 1.606500000 2.718940 1.614600000 2.648717 1.622800000 2.579452 1.631000000 2.511976 1.639300000 2.445453 1.647700000 2.379898 1.656100000 2.316077 1.664700000 2.252485 1.673300000 2.190615 1.682000000 2.129730 1.690700000 2.070511 1.699600000 2.011610 1.708500000 1.954357 1.717500000 1.898092 1.726600000 1.842821 1.735800000 1.788551 1.745000000 1.735851 1.754400000 1.683580 1.763800000 1.632854 1.773400000 1.582596 1.783000000 1.533854 1.792700000 1.486098 1.802600000 1.438858 1.812500000 1.393087 1.822600000 1.347859 1.832700000 1.304065 1.843000000 1.260834 1.853400000 1.218601 1.863900000 1.177362 1.874500000 1.137107 1.885300000 1.097471 1.896100000 1.059177 1.907100000 1.021507 1.918200000 0.984812 1.929500000 0.948767 1.940900000 0.913697 1.952400000 0.879589 1.964100000 0.846149 1.975900000 0.813664 1.987900000 0.781860 2.000000000 0.751000 ]
alter @vmm[pwl] = [ 0.000100000 -15.052534 1.073200000 -15.052534 1.073300000 -15.051080 1.073400000 -15.046697 1.076300000 -14.907723 1.078900000 -14.784088 1.081600000 -14.656779 1.084300000 -14.530562 1.088600000 -14.331781 1.092900000 -14.135710 1.097500000 -13.928916 1.102200000 -13.720738 1.106900000 -13.515659 1.111600000 -13.313633 1.116400000 -13.110413 1.121200000 -12.910281 1.126100000 -12.709117 1.131000000 -12.511074 1.135900000 -12.316103 1.140800000 -12.124158 1.145800000 -11.931364 1.150800000 -11.741622 1.155800000 -11.554883 1.160900000 -11.367454 1.166000000 -11.183051 1.171100000 -11.001624 1.176200000 -10.823126 1.181400000 -10.644094 1.186600000 -10.468008 1.191900000 -10.291517 1.197200000 -10.117986 1.202500000 -9.947366 1.207800000 -9.779606 1.213200000 -9.611574 1.218600000 -9.446413 1.224000000 -9.284074 1.229400000 -9.124507 1.234900000 -8.964788 1.240400000 -8.807847 1.246000000 -8.650858 1.251600000 -8.496649 1.257200000 -8.345171 1.262800000 -8.196376 1.268500000 -8.047630 1.274200000 -7.901564 1.280000000 -7.755639 1.285800000 -7.612389 1.291600000 -7.471766 1.297500000 -7.331363 1.303400000 -7.193580 1.309300000 -7.058366 1.315300000 -6.923446 1.321300000 -6.791085 1.327300000 -6.661234 1.333400000 -6.531743 1.339500000 -6.404748 1.345700000 -6.278179 1.351900000 -6.154090 1.358200000 -6.030488 1.364500000 -5.909347 1.370800000 -5.790617 1.377200000 -5.672422 1.383600000 -5.556615 1.390100000 -5.441396 1.396600000 -5.328541 1.403100000 -5.218003 1.409700000 -5.108086 1.416400000 -4.998846 1.423100000 -4.891917 1.429800000 -4.787250 1.436500000 -4.684796 1.443300000 -4.583029 1.450100000 -4.483447 1.456900000 -4.386002 1.463800000 -4.289262 1.470800000 -4.193272 1.477800000 -4.099402 1.484900000 -4.006310 1.492000000 -3.915302 1.499200000 -3.825095 1.506400000 -3.736936 1.513700000 -3.649598 1.521100000 -3.563114 1.528500000 -3.478650 1.536000000 -3.395054 1.543500000 -3.313436 1.551100000 -3.232698 1.558700000 -3.153894 1.566400000 -3.075979 1.574200000 -2.998980 1.582000000 -2.923873 1.589900000 -2.849686 1.597900000 -2.776441 1.605900000 -2.705042 1.614000000 -2.634584 1.622200000 -2.565087 1.630500000 -2.496570 1.638800000 -2.429844 1.647200000 -2.364090 1.655600000 -2.300074 1.664200000 -2.236289 1.672800000 -2.174229 1.681500000 -2.113157 1.690200000 -2.053758 1.699100000 -1.994675 1.708000000 -1.937247 1.717000000 -1.880808 1.726100000 -1.825366 1.735300000 -1.770929 1.744600000 -1.717499 1.754000000 -1.665083 1.763400000 -1.614216 1.773000000 -1.563817 1.782600000 -1.514939 1.792300000 -1.467049 1.802200000 -1.419677 1.812200000 -1.373321 1.822300000 -1.327980 1.832500000 -1.283648 1.842800000 -1.240323 1.853200000 -1.197998 1.863700000 -1.156667 1.874300000 -1.116324 1.885100000 -1.076600 1.896000000 -1.037872 1.907000000 -1.000130 1.918100000 -0.963365 1.929400000 -0.927252 1.940800000 -0.892114 1.952400000 -0.857649 1.964100000 -0.824155 1.975900000 -0.791617 1.987900000 -0.759761 2.000000000 -0.728851 ]
alter @vpwl[pwl] = [ 0 1 1000 1 ]
alter @vis[pwl] = [ 0.000100000 1.201624e-02 1.000000000 1.201624e-02 1.000100000 1.164098e-02 1.000200000 6.903204e-03 1.000300000 1.029364e-03 1.000400000 1.867853e-05 1.000500000 1.842219e-06 1.000600000 2.408580e-07 1.000700000 3.258381e-08 1.000800000 4.618142e-09 1.000900000 7.220195e-10 1.001000000 1.591768e-10 1.001200000 4.011086e-11 2.000000000 -5.128377e-12 ]
alter @vip[pwl] = [ 0.000100000 1.226115e-08 1.000000000 1.226115e-08 1.000100000 1.270673e-08 1.000200000 7.889342e-09 1.000300000 4.091860e-09 1.000400000 5.834837e-08 1.000500000 1.698739e-06 1.000600000 2.388449e-07 1.000700000 3.248233e-08 1.000800000 4.608764e-09 1.000900000 7.206202e-10 1.001000000 1.587396e-10 1.002300000 -5.121514e-12 2.000000000 -5.128377e-12 ]
tran 1e-05 2.000000000002 0 1e-05
wrdata corto_u503_l41c$d v(mainjack) v(fixjack1) v(fixjack2)
wrdata corto_u503_l41c_stati$d v(xls.xs) v(xlp.xs) v(dep) v(ina) v(vplus) v(vminus) v(main_a) v(mainc) v(fixc1) v(fixc2)
destroy all
echo "corto_u503_l41c,corto_u503_l41c.dat,l41c_corto_u503,1000,0,10a0,100k,0.990000000,1000,2.000000000002,1e-05,evento,rif_corto_u503_l41c,-,0.0,6,A_ins" >> tb_v2_casopeggiore_manifest.csv
.endc

.end
