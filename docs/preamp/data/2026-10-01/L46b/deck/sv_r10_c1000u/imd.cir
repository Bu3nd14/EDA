imd - L46b: IMD CCIF 19+20 kHz, blocco B nei tre modi, livelli lo/hi; variante sv_r10_c1000u
* generato da L46b/script/genera.py
.include @REPO@/models/jfet/lsk489.lib
.include @REPO@/models/bjt_npn/mmbt5551.lib
.include @REPO@/models/bjt_pnp/mmbt5401.lib
.include @REPO@/models/bjt_npn/mje15032.lib
.include @REPO@/models/bjt_pnp/mje15033.lib
.include @REPO@/models/diodes/1n4148.lib
.include @REPO@/models/bjt_pnp/ls350.lib
.include @REPO@/docs/preamp/data/2026-10-01/L46b/inc/sv_r10_c1000u.inc

VPP VPLUS 0 DC 15
VMM VMINUS 0 DC -15
VS1 VSN VMIDS SIN(0 0.141421 19000)
VS2 VMIDS 0 SIN(0 0.141421 20000)
RSRC VSN IN 2500
CSTRAY RG 0 15p
CSTRAY10 RG10 0 15p
RRG RG 0 1G
RRG10 RG10 0 1G
RISO OUT OUTA 47
COUT OUTA JACK 4.7u
RBLEED JACK 0 220k
RLOAD JACK 0 10k
.options reltol=1e-6 abstol=1e-15 vntol=1e-9

.control
option itl1=1000
set numdgt=10
set fourgridsize=16384
set nfreqs=24
save out vsn
alter rrg = 1G
alter rrg10 = 1G
alter @vs1[sin] = [ 0 0.141421 19000 ]
alter @vs2[sin] = [ 0 0.141421 20000 ]
tran 0.02u 0.003 0 0.02u
echo "L46A_CASO modo=0 livello=lo freq=1000 ampin=0.141421"
fourier 1000 v(vsn) v(out)
destroy all
alter rrg = 1G
alter rrg10 = 1G
alter @vs1[sin] = [ 0 1.41421 19000 ]
alter @vs2[sin] = [ 0 1.41421 20000 ]
tran 0.02u 0.003 0 0.02u
echo "L46A_CASO modo=0 livello=hi freq=1000 ampin=1.41421"
fourier 1000 v(vsn) v(out)
destroy all
alter rrg = 0.1
alter rrg10 = 1G
alter @vs1[sin] = [ 0 0.0995925 19000 ]
alter @vs2[sin] = [ 0 0.0995925 20000 ]
tran 0.02u 0.003 0 0.02u
echo "L46A_CASO modo=3 livello=lo freq=1000 ampin=0.0995925"
fourier 1000 v(vsn) v(out)
destroy all
alter rrg = 0.1
alter rrg10 = 1G
alter @vs1[sin] = [ 0 0.995925 19000 ]
alter @vs2[sin] = [ 0 0.995925 20000 ]
tran 0.02u 0.003 0 0.02u
echo "L46A_CASO modo=3 livello=hi freq=1000 ampin=0.995925"
fourier 1000 v(vsn) v(out)
destroy all
alter rrg = 0.1
alter rrg10 = 0.1
alter @vs1[sin] = [ 0 0.0448672 19000 ]
alter @vs2[sin] = [ 0 0.0448672 20000 ]
tran 0.02u 0.003 0 0.02u
echo "L46A_CASO modo=10 livello=lo freq=1000 ampin=0.0448672"
fourier 1000 v(vsn) v(out)
destroy all
alter rrg = 0.1
alter rrg10 = 0.1
alter @vs1[sin] = [ 0 0.448672 19000 ]
alter @vs2[sin] = [ 0 0.448672 20000 ]
tran 0.02u 0.003 0 0.02u
echo "L46A_CASO modo=10 livello=hi freq=1000 ampin=0.448672"
fourier 1000 v(vsn) v(out)
destroy all
.endc
.end
