thd_10k - L46a: THD a 10000 Hz, blocco B nei tre modi, livelli lo/hi; variante drv_r3.48k_cm1n
* generato da L46a/script/genera.py
.include /Users/roberto/EDA/.claude/worktrees/L46a-compensazione/models/jfet/lsk489.lib
.include /Users/roberto/EDA/.claude/worktrees/L46a-compensazione/models/bjt_npn/mmbt5551.lib
.include /Users/roberto/EDA/.claude/worktrees/L46a-compensazione/models/bjt_pnp/mmbt5401.lib
.include /Users/roberto/EDA/.claude/worktrees/L46a-compensazione/models/bjt_npn/mje15032.lib
.include /Users/roberto/EDA/.claude/worktrees/L46a-compensazione/models/bjt_pnp/mje15033.lib
.include /Users/roberto/EDA/.claude/worktrees/L46a-compensazione/models/diodes/1n4148.lib
.include /Users/roberto/EDA/.claude/worktrees/L46a-compensazione/models/bjt_pnp/ls350.lib
.include /Users/roberto/EDA/.claude/worktrees/L46a-compensazione/docs/preamp/data/2026-10-01/L46a/inc/drv_r3.48k_cm1n.inc

VPP VPLUS 0 DC 15
VMM VMINUS 0 DC -15
VS VSN 0 SIN(0 0.282843 10000)
RSRC VSN IN 2500
CSTRAY RG 0 15p
CSTRAY10 RG10 0 15p
RRG RG 0 1G
RRG10 RG10 0 1G
RISO OUT OUTA 47
COUT OUTA JACK 4.7u
RBLEED JACK 0 220k
RLOAD JACK 0 10k
.options reltol=1e-6 abstol=1e-15 vntol=1e-9

.control
set numdgt=10
set fourgridsize=8192
set nfreqs=10
save out vsn
alter rrg = 1G
alter rrg10 = 1G
alter @vs[sin] = [ 0 0.282843 10000 ]
tran 4e-08 0.0022 0 4e-08
echo "L46A_CASO modo=0 livello=lo freq=10000 ampin=0.282843"
fourier 10000 v(vsn) v(out)
destroy all
alter rrg = 1G
alter rrg10 = 1G
alter @vs[sin] = [ 0 2.82843 10000 ]
tran 4e-08 0.0022 0 4e-08
echo "L46A_CASO modo=0 livello=hi freq=10000 ampin=2.82843"
fourier 10000 v(vsn) v(out)
destroy all
alter rrg = 0.1
alter rrg10 = 1G
alter @vs[sin] = [ 0 0.199185 10000 ]
tran 4e-08 0.0022 0 4e-08
echo "L46A_CASO modo=3 livello=lo freq=10000 ampin=0.199185"
fourier 10000 v(vsn) v(out)
destroy all
alter rrg = 0.1
alter rrg10 = 1G
alter @vs[sin] = [ 0 1.99185 10000 ]
tran 4e-08 0.0022 0 4e-08
echo "L46A_CASO modo=3 livello=hi freq=10000 ampin=1.99185"
fourier 10000 v(vsn) v(out)
destroy all
alter rrg = 0.1
alter rrg10 = 0.1
alter @vs[sin] = [ 0 0.0897344 10000 ]
tran 4e-08 0.0022 0 4e-08
echo "L46A_CASO modo=10 livello=lo freq=10000 ampin=0.0897344"
fourier 10000 v(vsn) v(out)
destroy all
alter rrg = 0.1
alter rrg10 = 0.1
alter @vs[sin] = [ 0 0.897344 10000 ]
tran 4e-08 0.0022 0 4e-08
echo "L46A_CASO modo=10 livello=hi freq=10000 ampin=0.897344"
fourier 10000 v(vsn) v(out)
destroy all
.endc
.end
