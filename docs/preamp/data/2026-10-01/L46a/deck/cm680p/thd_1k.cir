thd_1k - L46a: THD a 1000 Hz, blocco B nei tre modi, livelli lo/hi; variante cm680p
* generato da L46a/script/genera.py
.include @REPO@/models/jfet/lsk489.lib
.include @REPO@/models/bjt_npn/mmbt5551.lib
.include @REPO@/models/bjt_pnp/mmbt5401.lib
.include @REPO@/models/bjt_npn/mje15032.lib
.include @REPO@/models/bjt_pnp/mje15033.lib
.include @REPO@/models/diodes/1n4148.lib
.include @REPO@/models/bjt_pnp/ls350.lib
.include @REPO@/docs/preamp/data/2026-10-01/L46a/inc/cm680p.inc

VPP VPLUS 0 DC 15
VMM VMINUS 0 DC -15
VS VSN 0 SIN(0 0.282843 1000)
RSRC VSN IN 2500
CSTRAY RG 0 15p
CSTRAY10 RG10 0 15p
RRG RG 0 1G
RRG10 RG10 0 1G
RISO OUT OUTA 47
COUT OUTA JACK 4.7u
RBLEED JACK 0 220k
RLOAD JACK 0 10k
.options reltol=1e-6 abstol=1e-15 vntol=1e-9

.control
set numdgt=10
set fourgridsize=8192
set nfreqs=10
save out vsn
alter rrg = 1G
alter rrg10 = 1G
alter @vs[sin] = [ 0 0.282843 1000 ]
tran 4e-07 0.004 0 4e-07
echo "L46A_CASO modo=0 livello=lo freq=1000 ampin=0.282843"
fourier 1000 v(vsn) v(out)
destroy all
alter rrg = 1G
alter rrg10 = 1G
alter @vs[sin] = [ 0 2.82843 1000 ]
tran 4e-07 0.004 0 4e-07
echo "L46A_CASO modo=0 livello=hi freq=1000 ampin=2.82843"
fourier 1000 v(vsn) v(out)
destroy all
alter rrg = 0.1
alter rrg10 = 1G
alter @vs[sin] = [ 0 0.199185 1000 ]
tran 4e-07 0.004 0 4e-07
echo "L46A_CASO modo=3 livello=lo freq=1000 ampin=0.199185"
fourier 1000 v(vsn) v(out)
destroy all
alter rrg = 0.1
alter rrg10 = 1G
alter @vs[sin] = [ 0 1.99185 1000 ]
tran 4e-07 0.004 0 4e-07
echo "L46A_CASO modo=3 livello=hi freq=1000 ampin=1.99185"
fourier 1000 v(vsn) v(out)
destroy all
alter rrg = 0.1
alter rrg10 = 0.1
alter @vs[sin] = [ 0 0.0897344 1000 ]
tran 4e-07 0.004 0 4e-07
echo "L46A_CASO modo=10 livello=lo freq=1000 ampin=0.0897344"
fourier 1000 v(vsn) v(out)
destroy all
alter rrg = 0.1
alter rrg10 = 0.1
alter @vs[sin] = [ 0 0.897344 1000 ]
tran 4e-07 0.004 0 4e-07
echo "L46A_CASO modo=10 livello=hi freq=1000 ampin=0.897344"
fourier 1000 v(vsn) v(out)
destroy all
.endc
.end
