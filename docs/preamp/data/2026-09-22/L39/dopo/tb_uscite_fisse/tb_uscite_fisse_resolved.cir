tb_uscite_fisse.cir - E4 (Zout) ed E5 (rumore) sulle uscite fisse coi buffer (L17, ADR-023)
* Prima riga = titolo (docs/limitations.md #10).
*
* LA CATENA, come preamp_audio.py la cabla da L17:
*   sorgente -> BLOCCO A -> BUFFER F1 -> 47 R + 4.7 u -> J1 (Singxer, 10 k)
*                        -> BUFFER F2 -> 47 R + 4.7 u -> J2 (Stax, 50 k)
*                        -> attenuatore 10 k
* Tre GAINBLOCK da gain_block.subckt, guadagno unitario (R_g non montata).
* Il subckt porta R113 = 1 MEG sull'ingresso anche dei buffer, dove
* preamp_audio.py non la monta: in parallelo all'uscita del blocco A (~1 ohm)
* non conta, ne' per Zout ne' per il rumore.
*
* E4 - Zout AL JACK J1, carico tolto (RLD1 = 1 G), scarico da 470 k lasciato
*   perche' il circuito vero ce l'ha. 1 A AC iniettato nel jack, sorgente a
*   massa. Tre letture:
*     Z   = |v(J1)|       cio' che vede il cavo, condensatore compreso
*     ZR  = Re(v(J1))     E4 si legge ESCLUDENDO la reattanza del
*                         condensatore d'accoppiamento: il condensatore in
*                         serie e' reattanza pura, quindi resta la parte reale
*     ZN  = |v(OUTF1)|    il nodo d'uscita del buffer, prima dei 47 ohm
*   Verbo di E4: ZR < 100 ohm su 20 Hz - 20 kHz.
*
* E5 - rumore in uscita al jack, 20 Hz - 20 kHz, non pesato, catena intera
*   A -> F1 -> J1 col Singxer da 10 k. Tre sorgenti come tb_noise_breakdown:
*   1 ohm (intrinseco), 430 ohm (phono), 2.5 k. Verbo: < 9.90 uV, cioe' E5
*   meno le quote di ADR-020 e ADR-022. Piu', per scomporre, il rumore del
*   solo blocco A al suo nodo d'uscita con la sorgente da 430 ohm.
*
* *** IL RUMORE E' UN PAVIMENTO, NON UNA PREVISIONE *** (tb_zout_psrr_noise):
* KF = 0 in ogni segnaposto, nessun rumore 1/f.
*
* NOISE E PLOT: ogni `noise` e' seguita da `destroy all`, altrimenti il
* `setplot noise2` della successiva legge il plot vecchio (limitations #10).
*
* Nessun file si chiama tb_uscite_fisse_wrdata.txt: run_simulation.sh avvisa
* e converte i .txt al secondo passaggio. Le tabelle sono .csv da echo.

.include /Users/roberto/EDA/.claude/worktrees/L39/models/jfet/lsk489.lib
.include /Users/roberto/EDA/.claude/worktrees/L39/models/bjt_npn/mmbt5551.lib
.include /Users/roberto/EDA/.claude/worktrees/L39/models/bjt_pnp/mmbt5401.lib
.include /Users/roberto/EDA/.claude/worktrees/L39/models/bjt_npn/mje15032.lib
.include /Users/roberto/EDA/.claude/worktrees/L39/models/bjt_pnp/mje15033.lib
.include /Users/roberto/EDA/.claude/worktrees/L39/models/diodes/1n4148.lib
.include /Users/roberto/EDA/.claude/worktrees/L39/models/bjt_pnp/ls350.lib
.include /Users/roberto/EDA/.claude/worktrees/L39/spice/preamp/gain_block.subckt

VPP VPLUS 0 DC 15
VMM VMINUS 0 DC -15

VSRC SRCN 0 DC 0 AC 1
RSRC SRCN IN 430

XA IN OUTA FBA RGA RG10A VPLUS VMINUS GAINBLOCK
RRGA RGA 0 1G
RRG10A RG10A 0 1G
CRGA RGA 0 15p
CRG10A RG10A 0 15p
RATT OUTA 0 10k

XF1 OUTA OUTF1 FBF1 RGF1 RG10F1 VPLUS VMINUS GAINBLOCK
RRGF1 RGF1 0 1G
RRG10F1 RG10F1 0 1G
CRGF1 RGF1 0 15p
CRG10F1 RG10F1 0 15p
XF2 OUTA OUTF2 FBF2 RGF2 RG10F2 VPLUS VMINUS GAINBLOCK
RRGF2 RGF2 0 1G
RRG10F2 RG10F2 0 1G
CRGF2 RGF2 0 15p
CRG10F2 RG10F2 0 15p

RSEP1 OUTF1 FIX1 47
CFIX1 FIX1 J1 4.7u
RBL1  J1 0 470k
RLD1  J1 0 10k
IOUT  0 J1 DC 0 AC 0
RSEP2 OUTF2 FIX2 47
CFIX2 FIX2 J2 4.7u
RBL2  J2 0 470k
RLD2  J2 0 50k

.control
set t = .txt

echo "########## E4: Zout al jack J1, carico tolto ##########"
alter rld1 = 1G
alter @vsrc[acmag] = 0
alter @iout[acmag] = 1
ac dec 20 20 200k
let Z = mag(v(j1))
let ZR = real(v(j1))
let ZN = mag(v(outf1))
meas ac z20   find Z at=20
meas ac z1k   find Z at=1000
meas ac z20k  find Z at=20000
meas ac zr20  find ZR at=20
meas ac zr1k  find ZR at=1000
meas ac zr20k find ZR at=20000
meas ac zn20  find ZN at=20
meas ac zn1k  find ZN at=1000
meas ac zn20k find ZN at=20000
meas ac zrmax MAX ZR from=20 to=20000
print z20 z1k z20k zr20 zr1k zr20k zn20 zn1k zn20k zrmax
* La tabella NON si chiama tb_uscite_fisse_zout.csv: quel nome lo scrive il
* secondo passaggio di run_simulation.sh convertendo il .txt qui sotto, e la
* sovrascriverebbe in silenzio. Successo in L17 alla prima esecuzione.
echo "grandezza,f20,f1k,f20k,max_20_20k" > tb_uscite_fisse_e4.csv
echo "Z_jack_mag,$&z20,$&z1k,$&z20k," >> tb_uscite_fisse_e4.csv
echo "Z_jack_real,$&zr20,$&zr1k,$&zr20k,$&zrmax" >> tb_uscite_fisse_e4.csv
echo "Z_nodo_buffer_mag,$&zn20,$&zn1k,$&zn20k," >> tb_uscite_fisse_e4.csv
*   col1 Z  col3 ZR  col5 ZN   (colonne pari = frequenza)
wrdata tb_uscite_fisse_zout$t Z ZR ZN
destroy all
alter @iout[acmag] = 0
alter rld1 = 10k
alter @vsrc[acmag] = 1

echo "########## E5: rumore al jack J1, catena A -> F1, 20 Hz - 20 kHz ##########"
echo "nodo,rsrc,onoise_total_v,inoise_total_v" > tb_uscite_fisse_rumore.csv
foreach rs 1 430 2500
  alter rsrc = $rs
  noise v(j1) VSRC dec 50 20 20000 1
  setplot noise1
  wrdata tb_uscite_fisse_rumore_$rs$t onoise_spectrum inoise_spectrum
  setplot noise2
  echo "J1  RSRC=$rs"
  print onoise_total inoise_total
  echo "J1,$rs,$&onoise_total,$&inoise_total" >> tb_uscite_fisse_rumore.csv
  destroy all
end

echo "########## scomposizione: il solo blocco A, al suo nodo d'uscita ##########"
alter rsrc = 430
noise v(outa) VSRC dec 50 20 20000 1
setplot noise2
echo "OUTA  RSRC=430"
print onoise_total inoise_total
echo "OUTA,430,$&onoise_total,$&inoise_total" >> tb_uscite_fisse_rumore.csv
destroy all
.endc

.end
