tb_v2_mute_ldr.cir - V2 al jack col mute graduale a monte: due LDR VTL5C4 all'ingresso del blocco A, profilo v4 Td 6 s (ADR-038, L29b2, NC-028)
* Prima riga = titolo (docs/limitations.md #10).
* GENERATO da docs/preamp/data/2026-09-22/L29b2/deck/genera_tb_v2_mute_ldr.py: non si
* edita a mano. L'intestazione del generatore dice cosa c'e' dentro e come si corre.
*
* IL MODELLO DELLE CELLE e' comportamentale dal datasheet, con estrapolazione dichiarata
* sopra ~10 kOhm (models/optocoupler/vtl5c4_comportamentale.lib, curva B per entrambe).
* Ogni cifra di questo deck porta quell'etichetta. Il resto e' come nei deck di V2: tutto
* tranne LS352 e' segnaposto, LSK489 compreso (NC-017, NC-031).
*
* IL PROFILO v4. Serie, log-lineare a tratti in d: 0.02 A a d = 0; 0.0002 A a d = 0.1; 4.5e-06 A a d = 0.45; 1.9e-07 A a d = 0.75; 1e-08 A a d = 0.8; 1e-08 A a d = 1.
* Derivazione: 10 nA fino a d = 0,5, poi log-lineare fino a 20 mA a d = 1. d va da 0 a 1
* in Td = 6 s dall'inserzione e torna indietro con la stessa velocita' da dove si trova.
* Rele' al jack chiuso a t_ins + Td + 0,5 s, aperto a t_rel.
*
* TEMPI: inserzione a 1 s, rele' a 7.5 s, rilascio a 8.5 s, fine a 17.5 s; inversione a
* d = 0.75, cioe' a 5.5 s, fine a 13 s. Tono 2,7 V RMS, +10 dB, fase pi/2.
*
* ANALISI: scripts/v2_metodo.py analizza sul manifesto (tabella echo, nome
* tb_v2_mute_ldr_manifest.csv; nessun wrdata lo nomina, #25). t_grad = Td + 0,5 s.
* CONVENZIONE DI PERCORSO: `.include /Users/roberto/EDA/.claude/worktrees/L39/...` (tb_op.cir, L2-L3).

.include /Users/roberto/EDA/.claude/worktrees/L39/spice/preamp/placeholder_devices.lib
.include /Users/roberto/EDA/.claude/worktrees/L39/models/bjt_pnp/ls350.lib
.include /Users/roberto/EDA/.claude/worktrees/L39/docs/preamp/data/2026-09-22/L39/prima/gain_block_L29b2.subckt
.include /Users/roberto/EDA/.claude/worktrees/L39/models/optocoupler/vtl5c4_comportamentale.lib

* >>> CANALE - identico nei tre deck tb_v2_mute_*.cir (v2_metodo.py canale)
* TOLLERANZE (L29a, ripresa 2026-09-16): vedi il blocco esteso in
* tb_v2_mute_varianti.cir. vntol=1e-9 rendeva il deck non eseguibile (41 ore
* per una cella senza segnale); vntol=1e-6 la fa in 5,5 s e le cifre non
* cambiano - verificato, data/2026-09-16/L29a/tolleranze/.
.options reltol=1e-6 vntol=1e-6 abstol=1e-12
VPP VPLUS 0 DC 15
VMM VMINUS 0 DC -15

* ---- sorgente con inviluppo d'entrata ----
VAMP NAMP 0 DC 3.818
VFRQ NFRQ 0 DC 1000
VPHS NPHS 0 DC 0
VTEN NTEN 0 DC 0.3
BSRC SRC 0 V = V(NAMP) * sin(6.283185307179586*V(NFRQ)*time + V(NPHS))
+ * (0.5 - 0.5*cos(3.141592653589793*min(time/V(NTEN), 1)))
RSRC SRC SELA 1.5

* ---- stati dei contatti: t_ins, t_rel, durata graduale, netto(1)/graduale(0) ----
VTIJK NTIJK 0 DC 1000
VTRJK NTRJK 0 DC 2000
VTGJK NTGJK 0 DC 1
VMHJK NMHJK 0 DC 1
BSJKR SJKR 0 V = V(NMHJK)
+ * pwl(time - V(NTIJK), -1e4,0, 0,0, 1u,1, 150u,1, 151u,0, 300u,0, 301u,1, 450u,1, 451u,0, 520u,0, 521u,1, 1e4,1)
+ * pwl(time - V(NTRJK), -1e4,1, 0,1, 1u,0, 400u,0, 401u,1, 600u,1, 601u,0, 1e4,0)
+ + (1 - V(NMHJK)) * min(max((time - V(NTIJK))/V(NTGJK), 0), 1)
+ * (1 - min(max((time - V(NTRJK))/V(NTGJK), 0), 1))
RSJK SJKR SJK 1k
CSJK SJK 0 4.55n
VTIPRE NTIPRE 0 DC 1000
VTRPRE NTRPRE 0 DC 2000
VTGPRE NTGPRE 0 DC 1
VMHPRE NMHPRE 0 DC 1
BSPRER SPRER 0 V = V(NMHPRE)
+ * pwl(time - V(NTIPRE), -1e4,0, 0,0, 1u,1, 150u,1, 151u,0, 300u,0, 301u,1, 450u,1, 451u,0, 520u,0, 521u,1, 1e4,1)
+ * pwl(time - V(NTRPRE), -1e4,1, 0,1, 1u,0, 400u,0, 401u,1, 600u,1, 601u,0, 1e4,0)
+ + (1 - V(NMHPRE)) * min(max((time - V(NTIPRE))/V(NTGPRE), 0), 1)
+ * (1 - min(max((time - V(NTRPRE))/V(NTGPRE), 0), 1))
RSPRE SPRER SPRE 1k
CSPRE SPRE 0 4.55n
VTISER NTISER 0 DC 1000
VTRSER NTRSER 0 DC 2000
VTGSER NTGSER 0 DC 1
VMHSER NMHSER 0 DC 1
BSSERR SSERR 0 V = V(NMHSER)
+ * pwl(time - V(NTISER), -1e4,0, 0,0, 1u,1, 150u,1, 151u,0, 300u,0, 301u,1, 450u,1, 451u,0, 520u,0, 521u,1, 1e4,1)
+ * pwl(time - V(NTRSER), -1e4,1, 0,1, 1u,0, 400u,0, 401u,1, 600u,1, 601u,0, 1e4,0)
+ + (1 - V(NMHSER)) * min(max((time - V(NTISER))/V(NTGSER), 0), 1)
+ * (1 - min(max((time - V(NTRSER))/V(NTGSER), 0), 1))
RSSER SSERR SSER 1k
CSSER SSER 0 4.55n
VTISEL NTISEL 0 DC 1000
VTRSEL NTRSEL 0 DC 2000
VTGSEL NTGSEL 0 DC 1
VMHSEL NMHSEL 0 DC 1
BSSELR SSELR 0 V = V(NMHSEL)
+ * pwl(time - V(NTISEL), -1e4,0, 0,0, 1u,1, 150u,1, 151u,0, 300u,0, 301u,1, 450u,1, 451u,0, 520u,0, 521u,1, 1e4,1)
+ * pwl(time - V(NTRSEL), -1e4,1, 0,1, 1u,0, 400u,0, 401u,1, 600u,1, 601u,0, 1e4,0)
+ + (1 - V(NMHSEL)) * min(max((time - V(NTISEL))/V(NTGSEL), 0), 1)
+ * (1 - min(max((time - V(NTRSEL))/V(NTGSEL), 0), 1))
RSSEL SSELR SSEL 1k
CSSEL SSEL 0 4.55n

* ---- selettore d'ingresso: serie, s = 1 vuol dire APERTO ----
BSEL SELA INA I = V(SELA,INA) * pow(10, -12 + 13*(1 - V(SSEL)))

* ---------------- BLOCCO A: guadagno 1, R_g non montata ------------------
VOSA INA INAX DC 0
XA INAX OUTA FBA RGA RG10A VPLUS VMINUS GAINBLOCK
RRGA RGA 0 1G
CRGA RGA 0 15p
RRG10A RG10A 0 1G
CRG10A RG10A 0 15p

* Attenuatore da 10 k: RATTT a 1 mohm = manopola al massimo.
RATTT OUTA W 1m
RATTB W 0 10k

* ---------------- BUFFER DELLE FISSE (ADR-023): guadagno 1 ---------------
VOSF1 OUTA F1IN DC 0
XF1 F1IN OUTF1 FBF1 RGF1 RG10F1 VPLUS VMINUS GAINBLOCK
RRGF1 RGF1 0 1G
CRGF1 RGF1 0 15p
RRG10F1 RG10F1 0 1G
CRG10F1 RG10F1 0 15p
VOSF2 OUTA F2IN DC 0
XF2 F2IN OUTF2 FBF2 RGF2 RG10F2 VPLUS VMINUS GAINBLOCK
RRGF2 RGF2 0 1G
CRGF2 RGF2 0 15p
RRG10F2 RG10F2 0 1G
CRG10F2 RG10F2 0 15p

RSEP1 OUTF1 FIX1 47
BPRE1 FIX1 0 I = V(FIX1) * pow(10, -12 + 13*V(SPRE))
CFIX1 FIX1 FIXC1 4.7u
RBC1 FIXC1 0 1e12
RBY1 FIXC1 FIXJACK1 1m
BSER1 FIXC1 FIXJACK1 I = V(FIXC1,FIXJACK1) * pow(10, -12 + 13*(1 - V(SSER)))
BJK1 FIXJACK1 0 I = V(FIXJACK1) * pow(10, -12 + 13*V(SJK))
RBL1 FIXJACK1 0 470k
RLD1 FIXJACK1 0 100k

RSEP2 OUTF2 FIX2 47
BPRE2 FIX2 0 I = V(FIX2) * pow(10, -12 + 13*V(SPRE))
CFIX2 FIX2 FIXC2 4.7u
RBC2 FIXC2 0 1e12
RBY2 FIXC2 FIXJACK2 1m
BSER2 FIXC2 FIXJACK2 I = V(FIXC2,FIXJACK2) * pow(10, -12 + 13*(1 - V(SSER)))
BJK2 FIXJACK2 0 I = V(FIXJACK2) * pow(10, -12 + 13*V(SJK))
RBL2 FIXJACK2 0 470k
RLD2 FIXJACK2 0 100k

* ---------------- BLOCCO B: 0 / +3 / +10 dB, due rele' su R_g ------------
* Contatto aperto = 1 G + 15 pF, chiuso = alter ... = 0.1 (ADR-026):
*   0 dB   rrgb = 1G    rrg10b = 1G
*   +3 dB  rrgb = 0.1   rrg10b = 1G
*   +10 dB rrgb = 0.1   rrg10b = 0.1
VOSB W WB DC 0
XB WB OUTB FBB RGB RG10B VPLUS VMINUS GAINBLOCK
RRGB RGB 0 1G
CRGB RGB 0 15p
RRG10B RG10B 0 1G
CRG10B RG10B 0 15p
RISOM OUTB MAIN_A 47
BPREM MAIN_A 0 I = V(MAIN_A) * pow(10, -12 + 13*V(SPRE))
COUTM MAIN_A MAINC 4.7u
RBCM MAINC 0 1e12
RBYM MAINC MAINJACK 1m
BSERM MAINC MAINJACK I = V(MAINC,MAINJACK) * pow(10, -12 + 13*(1 - V(SSER)))
BJKM MAINJACK 0 I = V(MAINJACK) * pow(10, -12 + 13*V(SJK))
RBLM MAINJACK 0 220k
RLDM MAINJACK 0 100k
* <<< CANALE
* ---- L29b2: le due LDR e il loro comando, fuori dal blocco CANALE (ADR-038) ----
VTI NTI 0 DC 1000
VTR NTR 0 DC 2000
VTD NTD 0 DC 6
BDIN DIN 0 V = min(max((time - V(NTI))/V(NTD), 0), 1)
BDEP DEP 0 V = time < V(NTR) ? V(DIN) : max(min(max((V(NTR) - V(NTI))/V(NTD), 0), 1) - (time - V(NTR))/V(NTD), 0)
BILS 0 ALS I = pow(10, pwl(V(DEP), 0,-1.6990, 0.1,-3.6990, 0.45,-5.3468, 0.75,-6.7212, 0.8,-8.0000, 1,-8.0000))
BILP 0 ALP I = 1e-08 * pow(2e+06, min(max((V(DEP) - 0.5)/0.5, 0), 1))
* 10 M dall'anodo a massa: un LED col solo generatore non ha percorso in continua e l'op
* fallisce in silenzio (trappola di L29b). E' del banco, non della scheda.
RALS ALS 0 10MEG
RALP ALP 0 10MEG
RSRC2 SRC SRCX 1.5
XLS ALS 0 SRCX SELA VTL5C4_B
XLP ALP 0 INA 0 VTL5C4_B

.control
* limitations #30: il tempo a 16 cifre, prima di ogni wrdata
set numdgt=15
set d = .dat
save v(mainjack) v(fixjack1) v(fixjack2) v(xls.xs) v(xlp.xs) v(dep) v(ina)
echo "cella,file,variante,f_hz,amp,gm,rl,t_ins,t_rel,t_fine,tmax,tipo,rif_ins,rif_rel,t_grad" > tb_v2_mute_ldr_manifest.csv
* la sorgente passa dalla LDR in serie: RSRC del blocco a 1 T, il selettore chiuso
alter rsrc = 1e12
alter rrgb = 0.1
alter rrg10b = 0.1
alter vphs dc = 1.5707963267948966
alter vmhjk dc = 1
* ======== carico 100k su tutte e tre le uscite ========
alter rldm = 100k
alter rld1 = 100k
alter rld2 = 100k
* ---- 20 Hz, 100k ----
alter vamp dc = 3.818
alter vfrq dc = 20
alter vti dc = 1000
alter vtr dc = 2000
alter vtijk dc = 1000
alter vtrjk dc = 2000
tran 1e-05 17.5 0 1e-05
wrdata mai_20_100k$d v(mainjack) v(fixjack1) v(fixjack2)
destroy all
echo "mai_20_100k,mai_20_100k.dat,rif,20,3.818,10,100k,1.0,8.5,17.5,1e-05,rif_mai,-,-,0.0" >> tb_v2_mute_ldr_manifest.csv
alter vamp dc = 3.818
alter vfrq dc = 20
alter vti dc = -10
alter vtr dc = 1000
alter vtijk dc = -10
alter vtrjk dc = 1000
tran 1e-05 17.5 0 1e-05
wrdata sempre_20_100k$d v(mainjack) v(fixjack1) v(fixjack2)
destroy all
echo "sempre_20_100k,sempre_20_100k.dat,rif,20,3.818,10,100k,1.0,8.5,17.5,1e-05,rif_sempre,-,-,0.0" >> tb_v2_mute_ldr_manifest.csv
alter vamp dc = 3.818
alter vfrq dc = 20
alter vti dc = 1.0
alter vtr dc = 8.5
alter vtijk dc = 7.5
alter vtrjk dc = 8.5
tran 1e-05 17.5 0 1e-05
wrdata ev_20_100k$d v(mainjack) v(fixjack1) v(fixjack2)
wrdata ev_20_100k_stati$d v(xls.xs) v(xlp.xs) v(dep) v(ina)
destroy all
echo "ev_20_100k,ev_20_100k.dat,ldr_v4_td6,20,3.818,10,100k,1.0,8.5,17.5,1e-05,evento,sempre_20_100k,mai_20_100k,6.5" >> tb_v2_mute_ldr_manifest.csv
alter vamp dc = 3.818
alter vfrq dc = 20
alter vti dc = 1.0
alter vtr dc = 8.5
alter vtijk dc = 1000
alter vtrjk dc = 2000
tran 1e-05 17.5 0 1e-05
wrdata norele_20_100k$d v(mainjack) v(fixjack1) v(fixjack2)
wrdata norele_20_100k_stati$d v(xls.xs) v(xlp.xs) v(dep) v(ina)
destroy all
echo "norele_20_100k,norele_20_100k.dat,rif,20,3.818,10,100k,1.0,8.5,17.5,1e-05,rif_seq,-,-,0.0" >> tb_v2_mute_ldr_manifest.csv
echo "rele_20_100k,ev_20_100k.dat,rele_contro_norele,20,3.818,10,100k,7.5,8.5,17.5,1e-05,evento,norele_20_100k,norele_20_100k,0.0" >> tb_v2_mute_ldr_manifest.csv
alter vamp dc = 3.818
alter vfrq dc = 20
alter vti dc = 1.0
alter vtr dc = 5.5
alter vtijk dc = 1000
alter vtrjk dc = 2000
tran 1e-05 13.0 0 1e-05
wrdata inv_20_100k$d v(mainjack) v(fixjack1) v(fixjack2)
wrdata inv_20_100k_stati$d v(xls.xs) v(xlp.xs) v(dep) v(ina)
destroy all
echo "inv_20_100k,inv_20_100k.dat,inversione_d75,20,3.818,10,100k,1.0,5.5,13.0,1e-05,evento,sempre_20_100k,mai_20_100k,4.5" >> tb_v2_mute_ldr_manifest.csv
alter vamp dc = 3.818
alter vfrq dc = 20
alter vti dc = 1.0
alter vtr dc = 8.5
alter vtijk dc = 7.5
alter vtrjk dc = 8.5
tran 7e-06 17.5 0 7e-06
wrdata evp_20_100k$d v(mainjack) v(fixjack1) v(fixjack2)
destroy all
alter vamp dc = 3.818
alter vfrq dc = 20
alter vti dc = 1.0
alter vtr dc = 5.5
alter vtijk dc = 1000
alter vtrjk dc = 2000
tran 7e-06 13.0 0 7e-06
wrdata invp_20_100k$d v(mainjack) v(fixjack1) v(fixjack2)
destroy all
echo "pav_ev0_20_100k,evp_20_100k.dat,pavimento,20,3.818,10,100k,1.0,1000,17.5,7e-06,pav_num,ev_20_100k,-,0.0" >> tb_v2_mute_ldr_manifest.csv
echo "pav_ev1_20_100k,evp_20_100k.dat,pavimento,20,3.818,10,100k,7.5,1000,17.5,7e-06,pav_num,ev_20_100k,-,0.0" >> tb_v2_mute_ldr_manifest.csv
echo "pav_ev2_20_100k,evp_20_100k.dat,pavimento,20,3.818,10,100k,8.5,1000,17.5,7e-06,pav_num,ev_20_100k,-,0.0" >> tb_v2_mute_ldr_manifest.csv
echo "pav_inv_20_100k,invp_20_100k.dat,pavimento,20,3.818,10,100k,5.5,1000,13.0,7e-06,pav_num,inv_20_100k,-,0.0" >> tb_v2_mute_ldr_manifest.csv
* ---- 1000 Hz, 100k ----
alter vamp dc = 3.818
alter vfrq dc = 1000
alter vti dc = 1000
alter vtr dc = 2000
alter vtijk dc = 1000
alter vtrjk dc = 2000
tran 1e-05 17.5 0 1e-05
wrdata mai_1k_100k$d v(mainjack) v(fixjack1) v(fixjack2)
destroy all
echo "mai_1k_100k,mai_1k_100k.dat,rif,1000,3.818,10,100k,1.0,8.5,17.5,1e-05,rif_mai,-,-,0.0" >> tb_v2_mute_ldr_manifest.csv
alter vamp dc = 3.818
alter vfrq dc = 1000
alter vti dc = -10
alter vtr dc = 1000
alter vtijk dc = -10
alter vtrjk dc = 1000
tran 1e-05 17.5 0 1e-05
wrdata sempre_1k_100k$d v(mainjack) v(fixjack1) v(fixjack2)
destroy all
echo "sempre_1k_100k,sempre_1k_100k.dat,rif,1000,3.818,10,100k,1.0,8.5,17.5,1e-05,rif_sempre,-,-,0.0" >> tb_v2_mute_ldr_manifest.csv
alter vamp dc = 3.818
alter vfrq dc = 1000
alter vti dc = 1.0
alter vtr dc = 8.5
alter vtijk dc = 7.5
alter vtrjk dc = 8.5
tran 1e-05 17.5 0 1e-05
wrdata ev_1k_100k$d v(mainjack) v(fixjack1) v(fixjack2)
wrdata ev_1k_100k_stati$d v(xls.xs) v(xlp.xs) v(dep) v(ina)
destroy all
echo "ev_1k_100k,ev_1k_100k.dat,ldr_v4_td6,1000,3.818,10,100k,1.0,8.5,17.5,1e-05,evento,sempre_1k_100k,mai_1k_100k,6.5" >> tb_v2_mute_ldr_manifest.csv
alter vamp dc = 3.818
alter vfrq dc = 1000
alter vti dc = 1.0
alter vtr dc = 8.5
alter vtijk dc = 1000
alter vtrjk dc = 2000
tran 1e-05 17.5 0 1e-05
wrdata norele_1k_100k$d v(mainjack) v(fixjack1) v(fixjack2)
wrdata norele_1k_100k_stati$d v(xls.xs) v(xlp.xs) v(dep) v(ina)
destroy all
echo "norele_1k_100k,norele_1k_100k.dat,rif,1000,3.818,10,100k,1.0,8.5,17.5,1e-05,rif_seq,-,-,0.0" >> tb_v2_mute_ldr_manifest.csv
echo "rele_1k_100k,ev_1k_100k.dat,rele_contro_norele,1000,3.818,10,100k,7.5,8.5,17.5,1e-05,evento,norele_1k_100k,norele_1k_100k,0.0" >> tb_v2_mute_ldr_manifest.csv
alter vamp dc = 3.818
alter vfrq dc = 1000
alter vti dc = 1.0
alter vtr dc = 5.5
alter vtijk dc = 1000
alter vtrjk dc = 2000
tran 1e-05 13.0 0 1e-05
wrdata inv_1k_100k$d v(mainjack) v(fixjack1) v(fixjack2)
wrdata inv_1k_100k_stati$d v(xls.xs) v(xlp.xs) v(dep) v(ina)
destroy all
echo "inv_1k_100k,inv_1k_100k.dat,inversione_d75,1000,3.818,10,100k,1.0,5.5,13.0,1e-05,evento,sempre_1k_100k,mai_1k_100k,4.5" >> tb_v2_mute_ldr_manifest.csv
alter vamp dc = 3.818
alter vfrq dc = 1000
alter vti dc = 1.0
alter vtr dc = 8.5
alter vtijk dc = 7.5
alter vtrjk dc = 8.5
tran 7e-06 17.5 0 7e-06
wrdata evp_1k_100k$d v(mainjack) v(fixjack1) v(fixjack2)
destroy all
alter vamp dc = 3.818
alter vfrq dc = 1000
alter vti dc = 1.0
alter vtr dc = 5.5
alter vtijk dc = 1000
alter vtrjk dc = 2000
tran 7e-06 13.0 0 7e-06
wrdata invp_1k_100k$d v(mainjack) v(fixjack1) v(fixjack2)
destroy all
echo "pav_ev0_1k_100k,evp_1k_100k.dat,pavimento,1000,3.818,10,100k,1.0,1000,17.5,7e-06,pav_num,ev_1k_100k,-,0.0" >> tb_v2_mute_ldr_manifest.csv
echo "pav_ev1_1k_100k,evp_1k_100k.dat,pavimento,1000,3.818,10,100k,7.5,1000,17.5,7e-06,pav_num,ev_1k_100k,-,0.0" >> tb_v2_mute_ldr_manifest.csv
echo "pav_ev2_1k_100k,evp_1k_100k.dat,pavimento,1000,3.818,10,100k,8.5,1000,17.5,7e-06,pav_num,ev_1k_100k,-,0.0" >> tb_v2_mute_ldr_manifest.csv
echo "pav_inv_1k_100k,invp_1k_100k.dat,pavimento,1000,3.818,10,100k,5.5,1000,13.0,7e-06,pav_num,inv_1k_100k,-,0.0" >> tb_v2_mute_ldr_manifest.csv
* ---- 20000 Hz, 100k ----
alter vamp dc = 3.818
alter vfrq dc = 20000
alter vti dc = 1000
alter vtr dc = 2000
alter vtijk dc = 1000
alter vtrjk dc = 2000
tran 5e-07 17.5 0 5e-07
wrdata mai_20k_100k$d v(mainjack) v(fixjack1) v(fixjack2)
destroy all
echo "mai_20k_100k,mai_20k_100k.dat,rif,20000,3.818,10,100k,1.0,8.5,17.5,5e-07,rif_mai,-,-,0.0" >> tb_v2_mute_ldr_manifest.csv
alter vamp dc = 3.818
alter vfrq dc = 20000
alter vti dc = -10
alter vtr dc = 1000
alter vtijk dc = -10
alter vtrjk dc = 1000
tran 5e-07 17.5 0 5e-07
wrdata sempre_20k_100k$d v(mainjack) v(fixjack1) v(fixjack2)
destroy all
echo "sempre_20k_100k,sempre_20k_100k.dat,rif,20000,3.818,10,100k,1.0,8.5,17.5,5e-07,rif_sempre,-,-,0.0" >> tb_v2_mute_ldr_manifest.csv
alter vamp dc = 3.818
alter vfrq dc = 20000
alter vti dc = 1.0
alter vtr dc = 8.5
alter vtijk dc = 7.5
alter vtrjk dc = 8.5
tran 5e-07 17.5 0 5e-07
wrdata ev_20k_100k$d v(mainjack) v(fixjack1) v(fixjack2)
wrdata ev_20k_100k_stati$d v(xls.xs) v(xlp.xs) v(dep) v(ina)
destroy all
echo "ev_20k_100k,ev_20k_100k.dat,ldr_v4_td6,20000,3.818,10,100k,1.0,8.5,17.5,5e-07,evento,sempre_20k_100k,mai_20k_100k,6.5" >> tb_v2_mute_ldr_manifest.csv
alter vamp dc = 3.818
alter vfrq dc = 20000
alter vti dc = 1.0
alter vtr dc = 8.5
alter vtijk dc = 1000
alter vtrjk dc = 2000
tran 5e-07 17.5 0 5e-07
wrdata norele_20k_100k$d v(mainjack) v(fixjack1) v(fixjack2)
wrdata norele_20k_100k_stati$d v(xls.xs) v(xlp.xs) v(dep) v(ina)
destroy all
echo "norele_20k_100k,norele_20k_100k.dat,rif,20000,3.818,10,100k,1.0,8.5,17.5,5e-07,rif_seq,-,-,0.0" >> tb_v2_mute_ldr_manifest.csv
echo "rele_20k_100k,ev_20k_100k.dat,rele_contro_norele,20000,3.818,10,100k,7.5,8.5,17.5,5e-07,evento,norele_20k_100k,norele_20k_100k,0.0" >> tb_v2_mute_ldr_manifest.csv
alter vamp dc = 3.818
alter vfrq dc = 20000
alter vti dc = 1.0
alter vtr dc = 5.5
alter vtijk dc = 1000
alter vtrjk dc = 2000
tran 5e-07 13.0 0 5e-07
wrdata inv_20k_100k$d v(mainjack) v(fixjack1) v(fixjack2)
wrdata inv_20k_100k_stati$d v(xls.xs) v(xlp.xs) v(dep) v(ina)
destroy all
echo "inv_20k_100k,inv_20k_100k.dat,inversione_d75,20000,3.818,10,100k,1.0,5.5,13.0,5e-07,evento,sempre_20k_100k,mai_20k_100k,4.5" >> tb_v2_mute_ldr_manifest.csv
alter vamp dc = 3.818
alter vfrq dc = 20000
alter vti dc = 1.0
alter vtr dc = 8.5
alter vtijk dc = 7.5
alter vtrjk dc = 8.5
tran 3.5e-07 17.5 0 3.5e-07
wrdata evp_20k_100k$d v(mainjack) v(fixjack1) v(fixjack2)
destroy all
alter vamp dc = 3.818
alter vfrq dc = 20000
alter vti dc = 1.0
alter vtr dc = 5.5
alter vtijk dc = 1000
alter vtrjk dc = 2000
tran 3.5e-07 13.0 0 3.5e-07
wrdata invp_20k_100k$d v(mainjack) v(fixjack1) v(fixjack2)
destroy all
echo "pav_ev0_20k_100k,evp_20k_100k.dat,pavimento,20000,3.818,10,100k,1.0,1000,17.5,3.5e-07,pav_num,ev_20k_100k,-,0.0" >> tb_v2_mute_ldr_manifest.csv
echo "pav_ev1_20k_100k,evp_20k_100k.dat,pavimento,20000,3.818,10,100k,7.5,1000,17.5,3.5e-07,pav_num,ev_20k_100k,-,0.0" >> tb_v2_mute_ldr_manifest.csv
echo "pav_ev2_20k_100k,evp_20k_100k.dat,pavimento,20000,3.818,10,100k,8.5,1000,17.5,3.5e-07,pav_num,ev_20k_100k,-,0.0" >> tb_v2_mute_ldr_manifest.csv
echo "pav_inv_20k_100k,invp_20k_100k.dat,pavimento,20000,3.818,10,100k,5.5,1000,13.0,3.5e-07,pav_num,inv_20k_100k,-,0.0" >> tb_v2_mute_ldr_manifest.csv
* ---- A senza segnale, 100k ----
alter vamp dc = 0
alter vfrq dc = 1000
alter vti dc = 1000
alter vtr dc = 2000
alter vtijk dc = 1000
alter vtrjk dc = 2000
tran 1e-05 17.5 0 1e-05
wrdata lzmai_100k$d v(mainjack) v(fixjack1) v(fixjack2)
destroy all
echo "lzmai_100k,lzmai_100k.dat,rif,1000,0,10,100k,1.0,8.5,17.5,1e-05,rif_mai,-,-,0.0" >> tb_v2_mute_ldr_manifest.csv
alter vamp dc = 0
alter vfrq dc = 1000
alter vti dc = -10
alter vtr dc = 1000
alter vtijk dc = -10
alter vtrjk dc = 1000
tran 1e-05 17.5 0 1e-05
wrdata lzsempre_100k$d v(mainjack) v(fixjack1) v(fixjack2)
destroy all
echo "lzsempre_100k,lzsempre_100k.dat,rif,1000,0,10,100k,1.0,8.5,17.5,1e-05,rif_sempre,-,-,0.0" >> tb_v2_mute_ldr_manifest.csv
alter vamp dc = 0
alter vfrq dc = 1000
alter vti dc = 1.0
alter vtr dc = 8.5
alter vtijk dc = 7.5
alter vtrjk dc = 8.5
tran 1e-05 17.5 0 1e-05
wrdata lzev_100k$d v(mainjack) v(fixjack1) v(fixjack2)
wrdata lzev_100k_stati$d v(xls.xs) v(xlp.xs) v(dep) v(ina)
destroy all
echo "lzev_100k,lzev_100k.dat,ldr_v4_td6,1000,0,10,100k,1.0,8.5,17.5,1e-05,evento,lzsempre_100k,lzmai_100k,6.5" >> tb_v2_mute_ldr_manifest.csv
alter vamp dc = 0
alter vfrq dc = 1000
alter vti dc = 1.0
alter vtr dc = 5.5
alter vtijk dc = 1000
alter vtrjk dc = 2000
tran 1e-05 13.0 0 1e-05
wrdata lzinv_100k$d v(mainjack) v(fixjack1) v(fixjack2)
destroy all
echo "lzinv_100k,lzinv_100k.dat,inversione_d75,1000,0,10,100k,1.0,5.5,13.0,1e-05,evento,lzsempre_100k,lzmai_100k,4.5" >> tb_v2_mute_ldr_manifest.csv
* ======== carico 10k su tutte e tre le uscite ========
alter rldm = 10k
alter rld1 = 10k
alter rld2 = 10k
* ---- 20 Hz, 10k ----
alter vamp dc = 3.818
alter vfrq dc = 20
alter vti dc = 1000
alter vtr dc = 2000
alter vtijk dc = 1000
alter vtrjk dc = 2000
tran 1e-05 17.5 0 1e-05
wrdata mai_20_10k$d v(mainjack) v(fixjack1) v(fixjack2)
destroy all
echo "mai_20_10k,mai_20_10k.dat,rif,20,3.818,10,10k,1.0,8.5,17.5,1e-05,rif_mai,-,-,0.0" >> tb_v2_mute_ldr_manifest.csv
alter vamp dc = 3.818
alter vfrq dc = 20
alter vti dc = -10
alter vtr dc = 1000
alter vtijk dc = -10
alter vtrjk dc = 1000
tran 1e-05 17.5 0 1e-05
wrdata sempre_20_10k$d v(mainjack) v(fixjack1) v(fixjack2)
destroy all
echo "sempre_20_10k,sempre_20_10k.dat,rif,20,3.818,10,10k,1.0,8.5,17.5,1e-05,rif_sempre,-,-,0.0" >> tb_v2_mute_ldr_manifest.csv
alter vamp dc = 3.818
alter vfrq dc = 20
alter vti dc = 1.0
alter vtr dc = 8.5
alter vtijk dc = 7.5
alter vtrjk dc = 8.5
tran 1e-05 17.5 0 1e-05
wrdata ev_20_10k$d v(mainjack) v(fixjack1) v(fixjack2)
wrdata ev_20_10k_stati$d v(xls.xs) v(xlp.xs) v(dep) v(ina)
destroy all
echo "ev_20_10k,ev_20_10k.dat,ldr_v4_td6,20,3.818,10,10k,1.0,8.5,17.5,1e-05,evento,sempre_20_10k,mai_20_10k,6.5" >> tb_v2_mute_ldr_manifest.csv
alter vamp dc = 3.818
alter vfrq dc = 20
alter vti dc = 1.0
alter vtr dc = 8.5
alter vtijk dc = 1000
alter vtrjk dc = 2000
tran 1e-05 17.5 0 1e-05
wrdata norele_20_10k$d v(mainjack) v(fixjack1) v(fixjack2)
wrdata norele_20_10k_stati$d v(xls.xs) v(xlp.xs) v(dep) v(ina)
destroy all
echo "norele_20_10k,norele_20_10k.dat,rif,20,3.818,10,10k,1.0,8.5,17.5,1e-05,rif_seq,-,-,0.0" >> tb_v2_mute_ldr_manifest.csv
echo "rele_20_10k,ev_20_10k.dat,rele_contro_norele,20,3.818,10,10k,7.5,8.5,17.5,1e-05,evento,norele_20_10k,norele_20_10k,0.0" >> tb_v2_mute_ldr_manifest.csv
alter vamp dc = 3.818
alter vfrq dc = 20
alter vti dc = 1.0
alter vtr dc = 5.5
alter vtijk dc = 1000
alter vtrjk dc = 2000
tran 1e-05 13.0 0 1e-05
wrdata inv_20_10k$d v(mainjack) v(fixjack1) v(fixjack2)
wrdata inv_20_10k_stati$d v(xls.xs) v(xlp.xs) v(dep) v(ina)
destroy all
echo "inv_20_10k,inv_20_10k.dat,inversione_d75,20,3.818,10,10k,1.0,5.5,13.0,1e-05,evento,sempre_20_10k,mai_20_10k,4.5" >> tb_v2_mute_ldr_manifest.csv
alter vamp dc = 3.818
alter vfrq dc = 20
alter vti dc = 1.0
alter vtr dc = 8.5
alter vtijk dc = 7.5
alter vtrjk dc = 8.5
tran 7e-06 17.5 0 7e-06
wrdata evp_20_10k$d v(mainjack) v(fixjack1) v(fixjack2)
destroy all
alter vamp dc = 3.818
alter vfrq dc = 20
alter vti dc = 1.0
alter vtr dc = 5.5
alter vtijk dc = 1000
alter vtrjk dc = 2000
tran 7e-06 13.0 0 7e-06
wrdata invp_20_10k$d v(mainjack) v(fixjack1) v(fixjack2)
destroy all
echo "pav_ev0_20_10k,evp_20_10k.dat,pavimento,20,3.818,10,10k,1.0,1000,17.5,7e-06,pav_num,ev_20_10k,-,0.0" >> tb_v2_mute_ldr_manifest.csv
echo "pav_ev1_20_10k,evp_20_10k.dat,pavimento,20,3.818,10,10k,7.5,1000,17.5,7e-06,pav_num,ev_20_10k,-,0.0" >> tb_v2_mute_ldr_manifest.csv
echo "pav_ev2_20_10k,evp_20_10k.dat,pavimento,20,3.818,10,10k,8.5,1000,17.5,7e-06,pav_num,ev_20_10k,-,0.0" >> tb_v2_mute_ldr_manifest.csv
echo "pav_inv_20_10k,invp_20_10k.dat,pavimento,20,3.818,10,10k,5.5,1000,13.0,7e-06,pav_num,inv_20_10k,-,0.0" >> tb_v2_mute_ldr_manifest.csv
* ---- 1000 Hz, 10k ----
alter vamp dc = 3.818
alter vfrq dc = 1000
alter vti dc = 1000
alter vtr dc = 2000
alter vtijk dc = 1000
alter vtrjk dc = 2000
tran 1e-05 17.5 0 1e-05
wrdata mai_1k_10k$d v(mainjack) v(fixjack1) v(fixjack2)
destroy all
echo "mai_1k_10k,mai_1k_10k.dat,rif,1000,3.818,10,10k,1.0,8.5,17.5,1e-05,rif_mai,-,-,0.0" >> tb_v2_mute_ldr_manifest.csv
alter vamp dc = 3.818
alter vfrq dc = 1000
alter vti dc = -10
alter vtr dc = 1000
alter vtijk dc = -10
alter vtrjk dc = 1000
tran 1e-05 17.5 0 1e-05
wrdata sempre_1k_10k$d v(mainjack) v(fixjack1) v(fixjack2)
destroy all
echo "sempre_1k_10k,sempre_1k_10k.dat,rif,1000,3.818,10,10k,1.0,8.5,17.5,1e-05,rif_sempre,-,-,0.0" >> tb_v2_mute_ldr_manifest.csv
alter vamp dc = 3.818
alter vfrq dc = 1000
alter vti dc = 1.0
alter vtr dc = 8.5
alter vtijk dc = 7.5
alter vtrjk dc = 8.5
tran 1e-05 17.5 0 1e-05
wrdata ev_1k_10k$d v(mainjack) v(fixjack1) v(fixjack2)
wrdata ev_1k_10k_stati$d v(xls.xs) v(xlp.xs) v(dep) v(ina)
destroy all
echo "ev_1k_10k,ev_1k_10k.dat,ldr_v4_td6,1000,3.818,10,10k,1.0,8.5,17.5,1e-05,evento,sempre_1k_10k,mai_1k_10k,6.5" >> tb_v2_mute_ldr_manifest.csv
alter vamp dc = 3.818
alter vfrq dc = 1000
alter vti dc = 1.0
alter vtr dc = 8.5
alter vtijk dc = 1000
alter vtrjk dc = 2000
tran 1e-05 17.5 0 1e-05
wrdata norele_1k_10k$d v(mainjack) v(fixjack1) v(fixjack2)
wrdata norele_1k_10k_stati$d v(xls.xs) v(xlp.xs) v(dep) v(ina)
destroy all
echo "norele_1k_10k,norele_1k_10k.dat,rif,1000,3.818,10,10k,1.0,8.5,17.5,1e-05,rif_seq,-,-,0.0" >> tb_v2_mute_ldr_manifest.csv
echo "rele_1k_10k,ev_1k_10k.dat,rele_contro_norele,1000,3.818,10,10k,7.5,8.5,17.5,1e-05,evento,norele_1k_10k,norele_1k_10k,0.0" >> tb_v2_mute_ldr_manifest.csv
alter vamp dc = 3.818
alter vfrq dc = 1000
alter vti dc = 1.0
alter vtr dc = 5.5
alter vtijk dc = 1000
alter vtrjk dc = 2000
tran 1e-05 13.0 0 1e-05
wrdata inv_1k_10k$d v(mainjack) v(fixjack1) v(fixjack2)
wrdata inv_1k_10k_stati$d v(xls.xs) v(xlp.xs) v(dep) v(ina)
destroy all
echo "inv_1k_10k,inv_1k_10k.dat,inversione_d75,1000,3.818,10,10k,1.0,5.5,13.0,1e-05,evento,sempre_1k_10k,mai_1k_10k,4.5" >> tb_v2_mute_ldr_manifest.csv
alter vamp dc = 3.818
alter vfrq dc = 1000
alter vti dc = 1.0
alter vtr dc = 8.5
alter vtijk dc = 7.5
alter vtrjk dc = 8.5
tran 7e-06 17.5 0 7e-06
wrdata evp_1k_10k$d v(mainjack) v(fixjack1) v(fixjack2)
destroy all
alter vamp dc = 3.818
alter vfrq dc = 1000
alter vti dc = 1.0
alter vtr dc = 5.5
alter vtijk dc = 1000
alter vtrjk dc = 2000
tran 7e-06 13.0 0 7e-06
wrdata invp_1k_10k$d v(mainjack) v(fixjack1) v(fixjack2)
destroy all
echo "pav_ev0_1k_10k,evp_1k_10k.dat,pavimento,1000,3.818,10,10k,1.0,1000,17.5,7e-06,pav_num,ev_1k_10k,-,0.0" >> tb_v2_mute_ldr_manifest.csv
echo "pav_ev1_1k_10k,evp_1k_10k.dat,pavimento,1000,3.818,10,10k,7.5,1000,17.5,7e-06,pav_num,ev_1k_10k,-,0.0" >> tb_v2_mute_ldr_manifest.csv
echo "pav_ev2_1k_10k,evp_1k_10k.dat,pavimento,1000,3.818,10,10k,8.5,1000,17.5,7e-06,pav_num,ev_1k_10k,-,0.0" >> tb_v2_mute_ldr_manifest.csv
echo "pav_inv_1k_10k,invp_1k_10k.dat,pavimento,1000,3.818,10,10k,5.5,1000,13.0,7e-06,pav_num,inv_1k_10k,-,0.0" >> tb_v2_mute_ldr_manifest.csv
* ---- 20000 Hz, 10k ----
alter vamp dc = 3.818
alter vfrq dc = 20000
alter vti dc = 1000
alter vtr dc = 2000
alter vtijk dc = 1000
alter vtrjk dc = 2000
tran 5e-07 17.5 0 5e-07
wrdata mai_20k_10k$d v(mainjack) v(fixjack1) v(fixjack2)
destroy all
echo "mai_20k_10k,mai_20k_10k.dat,rif,20000,3.818,10,10k,1.0,8.5,17.5,5e-07,rif_mai,-,-,0.0" >> tb_v2_mute_ldr_manifest.csv
alter vamp dc = 3.818
alter vfrq dc = 20000
alter vti dc = -10
alter vtr dc = 1000
alter vtijk dc = -10
alter vtrjk dc = 1000
tran 5e-07 17.5 0 5e-07
wrdata sempre_20k_10k$d v(mainjack) v(fixjack1) v(fixjack2)
destroy all
echo "sempre_20k_10k,sempre_20k_10k.dat,rif,20000,3.818,10,10k,1.0,8.5,17.5,5e-07,rif_sempre,-,-,0.0" >> tb_v2_mute_ldr_manifest.csv
alter vamp dc = 3.818
alter vfrq dc = 20000
alter vti dc = 1.0
alter vtr dc = 8.5
alter vtijk dc = 7.5
alter vtrjk dc = 8.5
tran 5e-07 17.5 0 5e-07
wrdata ev_20k_10k$d v(mainjack) v(fixjack1) v(fixjack2)
wrdata ev_20k_10k_stati$d v(xls.xs) v(xlp.xs) v(dep) v(ina)
destroy all
echo "ev_20k_10k,ev_20k_10k.dat,ldr_v4_td6,20000,3.818,10,10k,1.0,8.5,17.5,5e-07,evento,sempre_20k_10k,mai_20k_10k,6.5" >> tb_v2_mute_ldr_manifest.csv
alter vamp dc = 3.818
alter vfrq dc = 20000
alter vti dc = 1.0
alter vtr dc = 8.5
alter vtijk dc = 1000
alter vtrjk dc = 2000
tran 5e-07 17.5 0 5e-07
wrdata norele_20k_10k$d v(mainjack) v(fixjack1) v(fixjack2)
wrdata norele_20k_10k_stati$d v(xls.xs) v(xlp.xs) v(dep) v(ina)
destroy all
echo "norele_20k_10k,norele_20k_10k.dat,rif,20000,3.818,10,10k,1.0,8.5,17.5,5e-07,rif_seq,-,-,0.0" >> tb_v2_mute_ldr_manifest.csv
echo "rele_20k_10k,ev_20k_10k.dat,rele_contro_norele,20000,3.818,10,10k,7.5,8.5,17.5,5e-07,evento,norele_20k_10k,norele_20k_10k,0.0" >> tb_v2_mute_ldr_manifest.csv
alter vamp dc = 3.818
alter vfrq dc = 20000
alter vti dc = 1.0
alter vtr dc = 5.5
alter vtijk dc = 1000
alter vtrjk dc = 2000
tran 5e-07 13.0 0 5e-07
wrdata inv_20k_10k$d v(mainjack) v(fixjack1) v(fixjack2)
wrdata inv_20k_10k_stati$d v(xls.xs) v(xlp.xs) v(dep) v(ina)
destroy all
echo "inv_20k_10k,inv_20k_10k.dat,inversione_d75,20000,3.818,10,10k,1.0,5.5,13.0,5e-07,evento,sempre_20k_10k,mai_20k_10k,4.5" >> tb_v2_mute_ldr_manifest.csv
alter vamp dc = 3.818
alter vfrq dc = 20000
alter vti dc = 1.0
alter vtr dc = 8.5
alter vtijk dc = 7.5
alter vtrjk dc = 8.5
tran 3.5e-07 17.5 0 3.5e-07
wrdata evp_20k_10k$d v(mainjack) v(fixjack1) v(fixjack2)
destroy all
alter vamp dc = 3.818
alter vfrq dc = 20000
alter vti dc = 1.0
alter vtr dc = 5.5
alter vtijk dc = 1000
alter vtrjk dc = 2000
tran 3.5e-07 13.0 0 3.5e-07
wrdata invp_20k_10k$d v(mainjack) v(fixjack1) v(fixjack2)
destroy all
echo "pav_ev0_20k_10k,evp_20k_10k.dat,pavimento,20000,3.818,10,10k,1.0,1000,17.5,3.5e-07,pav_num,ev_20k_10k,-,0.0" >> tb_v2_mute_ldr_manifest.csv
echo "pav_ev1_20k_10k,evp_20k_10k.dat,pavimento,20000,3.818,10,10k,7.5,1000,17.5,3.5e-07,pav_num,ev_20k_10k,-,0.0" >> tb_v2_mute_ldr_manifest.csv
echo "pav_ev2_20k_10k,evp_20k_10k.dat,pavimento,20000,3.818,10,10k,8.5,1000,17.5,3.5e-07,pav_num,ev_20k_10k,-,0.0" >> tb_v2_mute_ldr_manifest.csv
echo "pav_inv_20k_10k,invp_20k_10k.dat,pavimento,20000,3.818,10,10k,5.5,1000,13.0,3.5e-07,pav_num,inv_20k_10k,-,0.0" >> tb_v2_mute_ldr_manifest.csv
* ---- A senza segnale, 10k ----
alter vamp dc = 0
alter vfrq dc = 1000
alter vti dc = 1000
alter vtr dc = 2000
alter vtijk dc = 1000
alter vtrjk dc = 2000
tran 1e-05 17.5 0 1e-05
wrdata lzmai_10k$d v(mainjack) v(fixjack1) v(fixjack2)
destroy all
echo "lzmai_10k,lzmai_10k.dat,rif,1000,0,10,10k,1.0,8.5,17.5,1e-05,rif_mai,-,-,0.0" >> tb_v2_mute_ldr_manifest.csv
alter vamp dc = 0
alter vfrq dc = 1000
alter vti dc = -10
alter vtr dc = 1000
alter vtijk dc = -10
alter vtrjk dc = 1000
tran 1e-05 17.5 0 1e-05
wrdata lzsempre_10k$d v(mainjack) v(fixjack1) v(fixjack2)
destroy all
echo "lzsempre_10k,lzsempre_10k.dat,rif,1000,0,10,10k,1.0,8.5,17.5,1e-05,rif_sempre,-,-,0.0" >> tb_v2_mute_ldr_manifest.csv
alter vamp dc = 0
alter vfrq dc = 1000
alter vti dc = 1.0
alter vtr dc = 8.5
alter vtijk dc = 7.5
alter vtrjk dc = 8.5
tran 1e-05 17.5 0 1e-05
wrdata lzev_10k$d v(mainjack) v(fixjack1) v(fixjack2)
wrdata lzev_10k_stati$d v(xls.xs) v(xlp.xs) v(dep) v(ina)
destroy all
echo "lzev_10k,lzev_10k.dat,ldr_v4_td6,1000,0,10,10k,1.0,8.5,17.5,1e-05,evento,lzsempre_10k,lzmai_10k,6.5" >> tb_v2_mute_ldr_manifest.csv
alter vamp dc = 0
alter vfrq dc = 1000
alter vti dc = 1.0
alter vtr dc = 5.5
alter vtijk dc = 1000
alter vtrjk dc = 2000
tran 1e-05 13.0 0 1e-05
wrdata lzinv_10k$d v(mainjack) v(fixjack1) v(fixjack2)
destroy all
echo "lzinv_10k,lzinv_10k.dat,inversione_d75,1000,0,10,10k,1.0,5.5,13.0,1e-05,evento,lzsempre_10k,lzmai_10k,4.5" >> tb_v2_mute_ldr_manifest.csv
.endc

.end
