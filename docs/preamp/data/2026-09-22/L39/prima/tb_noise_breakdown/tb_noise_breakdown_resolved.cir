tb_noise_breakdown.cir - which devices actually make the noise (E5)
* Single-frequency noise summary at 1 kHz so ngspice prints the per-device
* contribution table, plus the integrated 20 Hz - 20 kHz totals for the five
* configurations that matter (L27 added E, the +3 dB mode of ADR-026).
* REMINDER: placeholder_devices.lib has KF = 0 everywhere. There is NO 1/f
* noise in any of this. These are thermal + shot noise only, i.e. a FLOOR.

.include /Users/roberto/EDA/.claude/worktrees/L39/spice/preamp/placeholder_devices.lib
* L22: the input current mirror is no longer a placeholder. It is an
* LS352 (ADR-018) and this is its VENDOR model - the only one in this
* deck. L33 (NC-031): the LSK489 is not a vendor model here. Its halves
* are LSK489X, a hand-written placeholder with KF=0; the vendor model
* models/jfet/lsk489.lib is included by no deck (Fase 4, NC-017). Every
* OTHER device here is a hand-written placeholder too, and none has 1/f.
.include /Users/roberto/EDA/.claude/worktrees/L39/models/bjt_pnp/ls350.lib
.include /Users/roberto/EDA/.claude/worktrees/L39/spice/preamp/gain_block_flat.inc

VPP VPLUS 0 DC 15
VMM VMINUS 0 DC -15
VSRC SRCN 0 DC 0 AC 1
RSRC SRCN IN 430

* Gain-relay contacts (L27, ADR-026): open = 15 pF + 1 G, closed = 0.1 ohm.
CSTRAY   RG   0 15p
RRG      RG   0 1G
CSTRAY10 RG10 0 15p
RRG10    RG10 0 1G

RISO   OUT OUTA 47
COUT   OUTA JACK 4.7u
RBLEED JACK 0 220k
RLOAD  JACK 0 100k

.control
echo "===== per-device noise contributions at 1 kHz, 0 dB mode, Rsrc=430 ====="
noise v(JACK) VSRC lin 2 1000 1001 1
destroy all

* --- wrdata (L5): uno spettro PER CONFIGURAZIONE ----------------------
* NOMI PARAMETRIZZATI: un `$var` dentro un nome di file non si chiude da
* solo - ngspice fa entrare nel nome della variabile anche `.`, `-` e `_`,
* quindi `wrdata x_$lbl.txt` cercherebbe la variabile "lbl.txt". Un `$`
* invece TERMINA il nome: la forma che funziona e' `$lbl$t` con t = ".txt".
* Misurato con una sonda in L5, non dedotto.
*
* DOVE: plot `noise1`. Un'analisi `noise` ne produce DUE - noise1 (densita'
* spettrale, 301 righe) e noise2 (integrato, 1 riga) - e il `setplot`
* decide quale si scrive. Il `wrdata` sta DENTRO il ciclo e PRIMA del
* `destroy all`: senza quel destroy la seconda `noise` creerebbe
* noise3/noise4 e il `setplot noise2` continuerebbe a leggere la PRIMA
* configurazione. E' docs/limitations.md #10, ed e' esattamente il difetto
* che L5 corregge in tb_zout_psrr_noise.cir - qui il ciclo lo evita gia'.
*
* COSA NON SI SCRIVE, di proposito:
*  - la sezione per dispositivo a 1 kHz qui sopra: e' gia' il lavoro di
*    tb_noise_vectors.cir (L4). Due file per lo stesso dato divergono.
*  - gli integrati onoise_total/inoise_total: sono scalari, restano
*    stampati nel log, e la cifra credibile arrivera' con i modelli vendor.
*
* COLONNE (301 righe, 20 Hz - 20 kHz, 100 punti/decade). Per ogni vettore
* una COPPIA (frequenza, valore): le colonne PARI sono la frequenza
* ripetuta, i dati sono le DISPARI.
*   col0 = frequenza [Hz]   col1 = onoise_spectrum [V/sqrt(Hz)]
*   col2 = frequenza [Hz]   col3 = inoise_spectrum [V/sqrt(Hz)]
* La configurazione non e' una colonna: e' nel NOME del file.
*
* NOTA: nessun file si chiama tb_noise_breakdown_wrdata.txt, quindi il
* percorso primario di run_simulation.sh avvisa e scrive un
* tb_noise_breakdown.json con rows: 0. E' atteso: i 5 file veri li
* converte il SECONDO passaggio, che guarda i file prodotti.
*
* ATTENZIONE DI MERITO: KF = 0 su ogni dispositivo segnaposto, quindi qui
* NON c'e' rumore 1/f. E' un pavimento termico+shot, non una previsione, e
* per questo non va nel dossier finche' non ci sono i modelli vendor.
* ---------------------------------------------------------------------
set t = .txt
echo "===== integrated totals, 20 Hz - 20 kHz ====="
foreach cfg 1 2 3 4 5
  if $cfg = 1
    alter rrg = 1G
    alter rrg10 = 1G
    alter rsrc = 1
    set lbl = "a_0db_1r"
    echo "A) 0 dB, source 1 ohm      (block A intrinsic)"
  end
  if $cfg = 2
    alter rrg = 1G
    alter rrg10 = 1G
    alter rsrc = 430
    set lbl = "b_0db_430r"
    echo "B) 0 dB, source 430 ohm    (block A on the tube phono)"
  end
  if $cfg = 3
    alter rrg = 1G
    alter rrg10 = 1G
    alter rsrc = 2500
    set lbl = "c_0db_2500r"
    echo "C) 0 dB, source 2500 ohm   (block B, attenuator mid-rotation)"
  end
  if $cfg = 4
    alter rrg = 0.1
    alter rrg10 = 0.1
    alter rsrc = 2500
    set lbl = "d_10db_2500r"
    echo "D) +10 dB, source 2500 ohm (block B worst case)"
  end
  if $cfg = 5
    alter rrg = 0.1
    alter rrg10 = 1G
    alter rsrc = 2500
    set lbl = "e_3db_2500r"
    echo "E) +3 dB, source 2500 ohm  (block B, K1 closed, K5 open)"
  end
  noise v(JACK) VSRC dec 100 20 20000 1
  setplot noise1
  wrdata tb_noise_breakdown_$lbl$t onoise_spectrum inoise_spectrum
  setplot noise2
  print onoise_total inoise_total
  destroy all
end
.endc

.end
