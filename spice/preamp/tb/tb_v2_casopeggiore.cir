tb_v2_casopeggiore.cir - V2 al jack, il caso peggiore col mute reale: LDR VTL5C4 v4 a monte e rele' al jack, guadagno, trim, dispersione, accensione (L29c, NC-028)
* Prima riga = titolo (docs/limitations.md #10).
* GENERATO da docs/preamp/data/2026-09-23/L29c/deck/genera_tb_v2_casopeggiore.py: non si
* edita a mano. L'intestazione del generatore dice cosa c'e' dentro, le ipotesi di
* accensione e spegnimento, e come si corre. Matrice: l29c. Curve: serie B, derivazione B.
*
* IL MODELLO DELLE CELLE e' comportamentale dal datasheet, con estrapolazione dichiarata
* (models/optocoupler/vtl5c4_comportamentale.lib). Ogni dispositivo attivo e' il modello del
* costruttore in models/ (L39); nessuno porta la dispersione, che qui si inietta: VOS* e
* `altermod lsk489a vto` (gruppo B, ADR-031). UN MODELLO ALTERATO PORTA ANCORA IL NOME
* LSK489A (limitations #29): le corse alterate lo dicono nel nome (_gb*) e stampano showmod
* e la corrente della sonda JPRB.
*
* IL PROFILO v4, Td 6 s (ADR-039, ADR-040). Rele' al jack chiuso 0,5 s dopo d = 1.
* ANALISI: scripts/v2_metodo.py analizza sul manifesto; le colonne gruppo e conta dicono
* quali grandezze di ogni riga sono verdetto. Si corre DIVISO (dividi.py): le corse di
* accensione alterano le sorgenti dei rail, e in sequenza l'alterazione resterebbe.
* CONVENZIONE DI PERCORSO: `.include @REPO@/...` (tb_op.cir, L2-L3).

.include @REPO@/models/jfet/lsk489.lib
.include @REPO@/models/bjt_npn/mmbt5551.lib
.include @REPO@/models/bjt_pnp/mmbt5401.lib
.include @REPO@/models/bjt_npn/mje15032.lib
.include @REPO@/models/bjt_pnp/mje15033.lib
.include @REPO@/models/diodes/1n4148.lib
.include @REPO@/models/bjt_pnp/ls350.lib
.include @REPO@/spice/preamp/gain_block.subckt
.include @REPO@/models/optocoupler/vtl5c4_comportamentale.lib

* >>> CANALE - identico nei tre deck tb_v2_mute_*.cir (v2_metodo.py canale)
* TOLLERANZE (L29a, ripresa 2026-09-16): vedi il blocco esteso in
* tb_v2_mute_varianti.cir. vntol=1e-9 rendeva il deck non eseguibile (41 ore
* per una cella senza segnale); vntol=1e-6 la fa in 5,5 s e le cifre non
* cambiano - verificato, data/2026-09-16/L29a/tolleranze/.
.options reltol=1e-6 vntol=1e-6 abstol=1e-12
VPP VPLUS 0 DC 15
VMM VMINUS 0 DC -15

* ---- sorgente con inviluppo d'entrata ----
VAMP NAMP 0 DC 3.818
VFRQ NFRQ 0 DC 1000
VPHS NPHS 0 DC 0
VTEN NTEN 0 DC 0.3
BSRC SRC 0 V = V(NAMP) * sin(6.283185307179586*V(NFRQ)*time + V(NPHS))
+ * (0.5 - 0.5*cos(3.141592653589793*min(time/V(NTEN), 1)))
RSRC SRC SELA 1.5

* ---- stati dei contatti: t_ins, t_rel, durata graduale, netto(1)/graduale(0) ----
VTIJK NTIJK 0 DC 1000
VTRJK NTRJK 0 DC 2000
VTGJK NTGJK 0 DC 1
VMHJK NMHJK 0 DC 1
BSJKR SJKR 0 V = V(NMHJK)
+ * pwl(time - V(NTIJK), -1e4,0, 0,0, 1u,1, 150u,1, 151u,0, 300u,0, 301u,1, 450u,1, 451u,0, 520u,0, 521u,1, 1e4,1)
+ * pwl(time - V(NTRJK), -1e4,1, 0,1, 1u,0, 400u,0, 401u,1, 600u,1, 601u,0, 1e4,0)
+ + (1 - V(NMHJK)) * min(max((time - V(NTIJK))/V(NTGJK), 0), 1)
+ * (1 - min(max((time - V(NTRJK))/V(NTGJK), 0), 1))
RSJK SJKR SJK 1k
CSJK SJK 0 4.55n
VTIPRE NTIPRE 0 DC 1000
VTRPRE NTRPRE 0 DC 2000
VTGPRE NTGPRE 0 DC 1
VMHPRE NMHPRE 0 DC 1
BSPRER SPRER 0 V = V(NMHPRE)
+ * pwl(time - V(NTIPRE), -1e4,0, 0,0, 1u,1, 150u,1, 151u,0, 300u,0, 301u,1, 450u,1, 451u,0, 520u,0, 521u,1, 1e4,1)
+ * pwl(time - V(NTRPRE), -1e4,1, 0,1, 1u,0, 400u,0, 401u,1, 600u,1, 601u,0, 1e4,0)
+ + (1 - V(NMHPRE)) * min(max((time - V(NTIPRE))/V(NTGPRE), 0), 1)
+ * (1 - min(max((time - V(NTRPRE))/V(NTGPRE), 0), 1))
RSPRE SPRER SPRE 1k
CSPRE SPRE 0 4.55n
VTISER NTISER 0 DC 1000
VTRSER NTRSER 0 DC 2000
VTGSER NTGSER 0 DC 1
VMHSER NMHSER 0 DC 1
BSSERR SSERR 0 V = V(NMHSER)
+ * pwl(time - V(NTISER), -1e4,0, 0,0, 1u,1, 150u,1, 151u,0, 300u,0, 301u,1, 450u,1, 451u,0, 520u,0, 521u,1, 1e4,1)
+ * pwl(time - V(NTRSER), -1e4,1, 0,1, 1u,0, 400u,0, 401u,1, 600u,1, 601u,0, 1e4,0)
+ + (1 - V(NMHSER)) * min(max((time - V(NTISER))/V(NTGSER), 0), 1)
+ * (1 - min(max((time - V(NTRSER))/V(NTGSER), 0), 1))
RSSER SSERR SSER 1k
CSSER SSER 0 4.55n
VTISEL NTISEL 0 DC 1000
VTRSEL NTRSEL 0 DC 2000
VTGSEL NTGSEL 0 DC 1
VMHSEL NMHSEL 0 DC 1
BSSELR SSELR 0 V = V(NMHSEL)
+ * pwl(time - V(NTISEL), -1e4,0, 0,0, 1u,1, 150u,1, 151u,0, 300u,0, 301u,1, 450u,1, 451u,0, 520u,0, 521u,1, 1e4,1)
+ * pwl(time - V(NTRSEL), -1e4,1, 0,1, 1u,0, 400u,0, 401u,1, 600u,1, 601u,0, 1e4,0)
+ + (1 - V(NMHSEL)) * min(max((time - V(NTISEL))/V(NTGSEL), 0), 1)
+ * (1 - min(max((time - V(NTRSEL))/V(NTGSEL), 0), 1))
RSSEL SSELR SSEL 1k
CSSEL SSEL 0 4.55n

* ---- selettore d'ingresso: serie, s = 1 vuol dire APERTO ----
BSEL SELA INA I = V(SELA,INA) * pow(10, -12 + 13*(1 - V(SSEL)))

* ---------------- BLOCCO A: guadagno 1, R_g non montata ------------------
VOSA INA INAX DC 0
XA INAX OUTA FBA RGA RG10A VPLUS VMINUS GAINBLOCK
RRGA RGA 0 1G
CRGA RGA 0 15p
RRG10A RG10A 0 1G
CRG10A RG10A 0 15p

* Attenuatore da 10 k: RATTT a 1 mohm = manopola al massimo.
RATTT OUTA W 1m
RATTB W 0 10k

* ---------------- BUFFER DELLE FISSE (ADR-023): guadagno 1 ---------------
VOSF1 OUTA F1IN DC 0
XF1 F1IN OUTF1 FBF1 RGF1 RG10F1 VPLUS VMINUS GAINBLOCK
RRGF1 RGF1 0 1G
CRGF1 RGF1 0 15p
RRG10F1 RG10F1 0 1G
CRG10F1 RG10F1 0 15p
VOSF2 OUTA F2IN DC 0
XF2 F2IN OUTF2 FBF2 RGF2 RG10F2 VPLUS VMINUS GAINBLOCK
RRGF2 RGF2 0 1G
CRGF2 RGF2 0 15p
RRG10F2 RG10F2 0 1G
CRG10F2 RG10F2 0 15p

RSEP1 OUTF1 FIX1 47
BPRE1 FIX1 0 I = V(FIX1) * pow(10, -12 + 13*V(SPRE))
CFIX1 FIX1 FIXC1 4.7u
RBC1 FIXC1 0 1e12
RBY1 FIXC1 FIXJACK1 1m
BSER1 FIXC1 FIXJACK1 I = V(FIXC1,FIXJACK1) * pow(10, -12 + 13*(1 - V(SSER)))
BJK1 FIXJACK1 0 I = V(FIXJACK1) * pow(10, -12 + 13*V(SJK))
RBL1 FIXJACK1 0 470k
RLD1 FIXJACK1 0 100k

RSEP2 OUTF2 FIX2 47
BPRE2 FIX2 0 I = V(FIX2) * pow(10, -12 + 13*V(SPRE))
CFIX2 FIX2 FIXC2 4.7u
RBC2 FIXC2 0 1e12
RBY2 FIXC2 FIXJACK2 1m
BSER2 FIXC2 FIXJACK2 I = V(FIXC2,FIXJACK2) * pow(10, -12 + 13*(1 - V(SSER)))
BJK2 FIXJACK2 0 I = V(FIXJACK2) * pow(10, -12 + 13*V(SJK))
RBL2 FIXJACK2 0 470k
RLD2 FIXJACK2 0 100k

* ---------------- BLOCCO B: 0 / +3 / +10 dB, due rele' su R_g ------------
* Contatto aperto = 1 G + 15 pF, chiuso = alter ... = 0.1 (ADR-026):
*   0 dB   rrgb = 1G    rrg10b = 1G
*   +3 dB  rrgb = 0.1   rrg10b = 1G
*   +10 dB rrgb = 0.1   rrg10b = 0.1
VOSB W WB DC 0
XB WB OUTB FBB RGB RG10B VPLUS VMINUS GAINBLOCK
RRGB RGB 0 1G
CRGB RGB 0 15p
RRG10B RG10B 0 1G
CRG10B RG10B 0 15p
RISOM OUTB MAIN_A 47
BPREM MAIN_A 0 I = V(MAIN_A) * pow(10, -12 + 13*V(SPRE))
COUTM MAIN_A MAINC 4.7u
RBCM MAINC 0 1e12
RBYM MAINC MAINJACK 1m
BSERM MAINC MAINJACK I = V(MAINC,MAINJACK) * pow(10, -12 + 13*(1 - V(SSER)))
BJKM MAINJACK 0 I = V(MAINJACK) * pow(10, -12 + 13*V(SJK))
RBLM MAINJACK 0 220k
RLDM MAINJACK 0 100k
* <<< CANALE
* ---- L29b2: le due LDR e il loro comando, fuori dal blocco CANALE (ADR-038) ----
VTI NTI 0 DC 1000
VTR NTR 0 DC 2000
VTD NTD 0 DC 6
BDIN DIN 0 V = min(max((time - V(NTI))/V(NTD), 0), 1)
BDEP DEP 0 V = time < V(NTR) ? V(DIN) : max(min(max((V(NTR) - V(NTI))/V(NTD), 0), 1) - (time - V(NTR))/V(NTD), 0)
BILS 0 ALS I = V(NPWL) * pow(10, pwl(V(DEP), 0,-1.6990, 0.1,-3.6990, 0.45,-5.3468, 0.75,-6.7212, 0.8,-8.0000, 1,-8.0000))
BILP 0 ALP I = V(NPWL) * 1e-08 * pow(2e+06, min(max((V(DEP) - 0.5)/0.5, 0), 1))
* 10 M dall'anodo a massa: un LED col solo generatore non ha percorso in continua e l'op
* fallisce in silenzio (trappola di L29b). E' del banco, non della scheda.
RALS ALS 0 10MEG
RALP ALP 0 10MEG
RSRC2 SRC SRCX 1.5
XLS ALS 0 SRCX SELA VTL5C4_B
XLP ALP 0 INA 0 VTL5C4_B

* ---- L29c: i contatti del guadagno, in parallelo a RRGB / RRG10B del blocco ----
VK1I NK1I 0 DC 0
VK1T NK1T 0 DC 1000
BK1R SK1R 0 V = (1 - V(NK1I)) * pwl(time - V(NK1T), -1e4,0, 0,0, 1u,1, 150u,1, 151u,0, 300u,0, 301u,1, 450u,1, 451u,0, 520u,0, 521u,1, 1e4,1)
+ + V(NK1I) * pwl(time - V(NK1T), -1e4,1, 0,1, 1u,0, 400u,0, 401u,1, 600u,1, 601u,0, 1e4,0)
RK1S SK1R SK1 1k
CK1S SK1 0 4.55n
BK1 RGB 0 I = V(RGB,0) * pow(10, -12 + 13*V(SK1))
VK5I NK5I 0 DC 0
VK5T NK5T 0 DC 1000
BK5R SK5R 0 V = (1 - V(NK5I)) * pwl(time - V(NK5T), -1e4,0, 0,0, 1u,1, 150u,1, 151u,0, 300u,0, 301u,1, 450u,1, 451u,0, 520u,0, 521u,1, 1e4,1)
+ + V(NK5I) * pwl(time - V(NK5T), -1e4,1, 0,1, 1u,0, 400u,0, 401u,1, 600u,1, 601u,0, 1e4,0)
RK5S SK5R SK5 1k
CK5S SK5 0 4.55n
BK5 RG10B 0 I = V(RG10B,0) * pow(10, -12 + 13*V(SK5))
* ---- L29c: il trim (ADR-027, trim.py candidato 2) fra OUTA e l'attenuatore ----
* RATTT del blocco si apre nel .control (alter rattt = 1e12): OUTA arriva a W da qui.
RL1 OUTA TAP6 845
RL2 TAP6 TAP12 464
RL3 TAP12 0 464
VT1RI NT1RI 0 DC 0
VT1RT NT1RT 0 DC 1000
BT1RR ST1RR 0 V = (1 - V(NT1RI)) * pwl(time - V(NT1RT), -1e4,0, 0,0, 1u,1, 150u,1, 151u,0, 300u,0, 301u,1, 450u,1, 451u,0, 520u,0, 521u,1, 1e4,1)
+ + V(NT1RI) * pwl(time - V(NT1RT), -1e4,1, 0,1, 1u,0, 400u,0, 401u,1, 600u,1, 601u,0, 1e4,0)
RT1RS ST1RR ST1R 1k
CT1RS ST1R 0 4.55n
BT1R OUTA ATOP I = V(OUTA,ATOP) * pow(10, -12 + 13*V(ST1R))
CT1RP OUTA ATOP 15p
VT1SI NT1SI 0 DC 0
VT1ST NT1ST 0 DC 1000
BT1SR ST1SR 0 V = (1 - V(NT1SI)) * pwl(time - V(NT1ST), -1e4,0, 0,0, 1u,1, 150u,1, 151u,0, 300u,0, 301u,1, 450u,1, 451u,0, 520u,0, 521u,1, 1e4,1)
+ + V(NT1SI) * pwl(time - V(NT1ST), -1e4,1, 0,1, 1u,0, 400u,0, 401u,1, 600u,1, 601u,0, 1e4,0)
RT1SS ST1SR ST1S 1k
CT1SS ST1S 0 4.55n
BT1S T2C ATOP I = V(T2C,ATOP) * pow(10, -12 + 13*V(ST1S))
CT1SP T2C ATOP 15p
VT2RI NT2RI 0 DC 0
VT2RT NT2RT 0 DC 1000
BT2RR ST2RR 0 V = (1 - V(NT2RI)) * pwl(time - V(NT2RT), -1e4,0, 0,0, 1u,1, 150u,1, 151u,0, 300u,0, 301u,1, 450u,1, 451u,0, 520u,0, 521u,1, 1e4,1)
+ + V(NT2RI) * pwl(time - V(NT2RT), -1e4,1, 0,1, 1u,0, 400u,0, 401u,1, 600u,1, 601u,0, 1e4,0)
RT2RS ST2RR ST2R 1k
CT2RS ST2R 0 4.55n
BT2R TAP6 T2C I = V(TAP6,T2C) * pow(10, -12 + 13*V(ST2R))
CT2RP TAP6 T2C 15p
VT2SI NT2SI 0 DC 0
VT2ST NT2ST 0 DC 1000
BT2SR ST2SR 0 V = (1 - V(NT2SI)) * pwl(time - V(NT2ST), -1e4,0, 0,0, 1u,1, 150u,1, 151u,0, 300u,0, 301u,1, 450u,1, 451u,0, 520u,0, 521u,1, 1e4,1)
+ + V(NT2SI) * pwl(time - V(NT2ST), -1e4,1, 0,1, 1u,0, 400u,0, 401u,1, 600u,1, 601u,0, 1e4,0)
RT2SS ST2SR ST2S 1k
CT2SS ST2S 0 4.55n
BT2S TAP12 T2C I = V(TAP12,T2C) * pow(10, -12 + 13*V(ST2S))
CT2SP TAP12 T2C 15p
CWIRE ATOP 0 100p
RATTH ATOP W 1m
* ---- L29c: la sonda del gruppo B (limitations #29), su nodi propri (#24) ----
VPRBD PRBD 0 DC 15
VPRBG PRBG 0 DC 0
JPRB PRBD PRBG 0 LSK489A
* ---- L29c: l'alimentazione del comando dei LED, 0..1, segue il rail positivo ----
VPWL NPWL 0 DC 1

.control
* limitations #30: il tempo a 16 cifre, prima di ogni wrdata
set numdgt=15
set d = .dat
save v(mainjack) v(fixjack1) v(fixjack2) v(xls.xs) v(xlp.xs) v(dep) v(ina) v(vplus) v(vminus) v(main_a)
echo "cella,file,variante,f_hz,amp,gm,rl,t_ins,t_rel,t_fine,tmax,tipo,rif_ins,rif_rel,t_grad,gruppo,conta" > tb_v2_casopeggiore_manifest.csv
* la sorgente passa dalla LDR in serie: RSRC del blocco a 1 T, il selettore chiuso
alter rsrc = 1e12
alter vphs dc = 1.5707963267948966
alter vmhjk dc = 1
* il trim porta OUTA all'attenuatore: RATTT del blocco aperto
alter rattt = 1e12
* ---- riferimenti 1k ----
alter vamp dc = 3.818
alter vfrq dc = 1000
alter rldm = 100k
alter rld1 = 100k
alter rld2 = 100k
alter vti dc = 1000
alter vtr dc = 2000
alter vtijk dc = 1000
alter vtrjk dc = 2000
alter vosa dc = 0
alter vosb dc = 0
alter vosf1 dc = 0
alter vosf2 dc = 0
alter ratth = 1m
alter rattb = 10k
alter rl1 = 845
alter cwire = 100p
alter vk1i dc = 1
alter vk1t dc = 1000.000000
alter vk5i dc = 1
alter vk5t dc = 1000.000000
alter vt1ri dc = 1
alter vt1rt dc = 1000.000000
alter vt1si dc = 0
alter vt1st dc = 1000.000000
alter vt2ri dc = 1
alter vt2rt dc = 1000.000000
alter vt2si dc = 0
alter vt2st dc = 1000.000000
tran 1e-05 36.5 0 1e-05
wrdata g10mai_1k$d v(mainjack) v(fixjack1) v(fixjack2)
wrdata g10mai_1k_stati$d v(xls.xs) v(xlp.xs) v(dep) v(ina) v(vplus) v(vminus) v(main_a)
destroy all
alter vamp dc = 3.818
alter vfrq dc = 1000
alter rldm = 100k
alter rld1 = 100k
alter rld2 = 100k
alter vti dc = -10
alter vtr dc = 1000
alter vtijk dc = -10
alter vtrjk dc = 1000
alter vosa dc = 0
alter vosb dc = 0
alter vosf1 dc = 0
alter vosf2 dc = 0
alter ratth = 1m
alter rattb = 10k
alter rl1 = 845
alter cwire = 100p
alter vk1i dc = 1
alter vk1t dc = 1000.000000
alter vk5i dc = 1
alter vk5t dc = 1000.000000
alter vt1ri dc = 1
alter vt1rt dc = 1000.000000
alter vt1si dc = 0
alter vt1st dc = 1000.000000
alter vt2ri dc = 1
alter vt2rt dc = 1000.000000
alter vt2si dc = 0
alter vt2st dc = 1000.000000
tran 1e-05 36.5 0 1e-05
wrdata g10sempre_1k$d v(mainjack) v(fixjack1) v(fixjack2)
wrdata g10sempre_1k_stati$d v(xls.xs) v(xlp.xs) v(dep) v(ina) v(vplus) v(vminus) v(main_a)
destroy all
echo "g10mai_1k,g10mai_1k.dat,rif,1000,3.818,10,100k,1.0,8.5,36.5,1e-05,rif_mai,-,-,0.0,0," >> tb_v2_casopeggiore_manifest.csv
echo "g10sempre_1k,g10sempre_1k.dat,rif,1000,3.818,10,100k,1.0,8.5,36.5,1e-05,rif_sempre,-,-,0.0,0," >> tb_v2_casopeggiore_manifest.csv
alter vamp dc = 3.818
alter vfrq dc = 1000
alter rldm = 100k
alter rld1 = 100k
alter rld2 = 100k
alter vti dc = 1000
alter vtr dc = 2000
alter vtijk dc = 1000
alter vtrjk dc = 2000
alter vosa dc = 0
alter vosb dc = 0
alter vosf1 dc = 0
alter vosf2 dc = 0
alter ratth = 1m
alter rattb = 10k
alter rl1 = 845
alter cwire = 100p
alter vk1i dc = 0
alter vk1t dc = 1000.000000
alter vk5i dc = 0
alter vk5t dc = 1000.000000
alter vt1ri dc = 1
alter vt1rt dc = 1000.000000
alter vt1si dc = 0
alter vt1st dc = 1000.000000
alter vt2ri dc = 1
alter vt2rt dc = 1000.000000
alter vt2si dc = 0
alter vt2st dc = 1000.000000
tran 1e-05 19.0 0 1e-05
wrdata g0mai_1k$d v(mainjack) v(fixjack1) v(fixjack2)
wrdata g0mai_1k_stati$d v(xls.xs) v(xlp.xs) v(dep) v(ina) v(vplus) v(vminus) v(main_a)
destroy all
alter vamp dc = 3.818
alter vfrq dc = 1000
alter rldm = 100k
alter rld1 = 100k
alter rld2 = 100k
alter vti dc = -10
alter vtr dc = 1000
alter vtijk dc = -10
alter vtrjk dc = 1000
alter vosa dc = 0
alter vosb dc = 0
alter vosf1 dc = 0
alter vosf2 dc = 0
alter ratth = 1m
alter rattb = 10k
alter rl1 = 845
alter cwire = 100p
alter vk1i dc = 0
alter vk1t dc = 1000.000000
alter vk5i dc = 0
alter vk5t dc = 1000.000000
alter vt1ri dc = 1
alter vt1rt dc = 1000.000000
alter vt1si dc = 0
alter vt1st dc = 1000.000000
alter vt2ri dc = 1
alter vt2rt dc = 1000.000000
alter vt2si dc = 0
alter vt2st dc = 1000.000000
tran 1e-05 19.0 0 1e-05
wrdata g0sempre_1k$d v(mainjack) v(fixjack1) v(fixjack2)
wrdata g0sempre_1k_stati$d v(xls.xs) v(xlp.xs) v(dep) v(ina) v(vplus) v(vminus) v(main_a)
destroy all
echo "g0mai_1k,g0mai_1k.dat,rif,1000,3.818,0,100k,1.0,8.5,19.0,1e-05,rif_mai,-,-,0.0,0," >> tb_v2_casopeggiore_manifest.csv
echo "g0sempre_1k,g0sempre_1k.dat,rif,1000,3.818,0,100k,1.0,8.5,19.0,1e-05,rif_sempre,-,-,0.0,0," >> tb_v2_casopeggiore_manifest.csv
alter vamp dc = 3.818
alter vfrq dc = 1000
alter rldm = 100k
alter rld1 = 100k
alter rld2 = 100k
alter vti dc = 1000
alter vtr dc = 2000
alter vtijk dc = 1000
alter vtrjk dc = 2000
alter vosa dc = 0
alter vosb dc = 0
alter vosf1 dc = 0
alter vosf2 dc = 0
alter ratth = 1m
alter rattb = 10k
alter rl1 = 845
alter cwire = 100p
alter vk1i dc = 1
alter vk1t dc = 1000.000000
alter vk5i dc = 0
alter vk5t dc = 1000.000000
alter vt1ri dc = 1
alter vt1rt dc = 1000.000000
alter vt1si dc = 0
alter vt1st dc = 1000.000000
alter vt2ri dc = 1
alter vt2rt dc = 1000.000000
alter vt2si dc = 0
alter vt2st dc = 1000.000000
tran 1e-05 19.0 0 1e-05
wrdata g3mai_1k$d v(mainjack) v(fixjack1) v(fixjack2)
wrdata g3mai_1k_stati$d v(xls.xs) v(xlp.xs) v(dep) v(ina) v(vplus) v(vminus) v(main_a)
destroy all
alter vamp dc = 3.818
alter vfrq dc = 1000
alter rldm = 100k
alter rld1 = 100k
alter rld2 = 100k
alter vti dc = -10
alter vtr dc = 1000
alter vtijk dc = -10
alter vtrjk dc = 1000
alter vosa dc = 0
alter vosb dc = 0
alter vosf1 dc = 0
alter vosf2 dc = 0
alter ratth = 1m
alter rattb = 10k
alter rl1 = 845
alter cwire = 100p
alter vk1i dc = 1
alter vk1t dc = 1000.000000
alter vk5i dc = 0
alter vk5t dc = 1000.000000
alter vt1ri dc = 1
alter vt1rt dc = 1000.000000
alter vt1si dc = 0
alter vt1st dc = 1000.000000
alter vt2ri dc = 1
alter vt2rt dc = 1000.000000
alter vt2si dc = 0
alter vt2st dc = 1000.000000
tran 1e-05 19.0 0 1e-05
wrdata g3sempre_1k$d v(mainjack) v(fixjack1) v(fixjack2)
wrdata g3sempre_1k_stati$d v(xls.xs) v(xlp.xs) v(dep) v(ina) v(vplus) v(vminus) v(main_a)
destroy all
echo "g3mai_1k,g3mai_1k.dat,rif,1000,3.818,3,100k,1.0,8.5,19.0,1e-05,rif_mai,-,-,0.0,0," >> tb_v2_casopeggiore_manifest.csv
echo "g3sempre_1k,g3sempre_1k.dat,rif,1000,3.818,3,100k,1.0,8.5,19.0,1e-05,rif_sempre,-,-,0.0,0," >> tb_v2_casopeggiore_manifest.csv
* ---- riferimenti 20 ----
alter vamp dc = 3.818
alter vfrq dc = 20
alter rldm = 100k
alter rld1 = 100k
alter rld2 = 100k
alter vti dc = 1000
alter vtr dc = 2000
alter vtijk dc = 1000
alter vtrjk dc = 2000
alter vosa dc = 0
alter vosb dc = 0
alter vosf1 dc = 0
alter vosf2 dc = 0
alter ratth = 1m
alter rattb = 10k
alter rl1 = 845
alter cwire = 100p
alter vk1i dc = 1
alter vk1t dc = 1000.000000
alter vk5i dc = 1
alter vk5t dc = 1000.000000
alter vt1ri dc = 1
alter vt1rt dc = 1000.000000
alter vt1si dc = 0
alter vt1st dc = 1000.000000
alter vt2ri dc = 1
alter vt2rt dc = 1000.000000
alter vt2si dc = 0
alter vt2st dc = 1000.000000
tran 1e-05 36.5 0 1e-05
wrdata g10mai_20$d v(mainjack) v(fixjack1) v(fixjack2)
wrdata g10mai_20_stati$d v(xls.xs) v(xlp.xs) v(dep) v(ina) v(vplus) v(vminus) v(main_a)
destroy all
alter vamp dc = 3.818
alter vfrq dc = 20
alter rldm = 100k
alter rld1 = 100k
alter rld2 = 100k
alter vti dc = -10
alter vtr dc = 1000
alter vtijk dc = -10
alter vtrjk dc = 1000
alter vosa dc = 0
alter vosb dc = 0
alter vosf1 dc = 0
alter vosf2 dc = 0
alter ratth = 1m
alter rattb = 10k
alter rl1 = 845
alter cwire = 100p
alter vk1i dc = 1
alter vk1t dc = 1000.000000
alter vk5i dc = 1
alter vk5t dc = 1000.000000
alter vt1ri dc = 1
alter vt1rt dc = 1000.000000
alter vt1si dc = 0
alter vt1st dc = 1000.000000
alter vt2ri dc = 1
alter vt2rt dc = 1000.000000
alter vt2si dc = 0
alter vt2st dc = 1000.000000
tran 1e-05 36.5 0 1e-05
wrdata g10sempre_20$d v(mainjack) v(fixjack1) v(fixjack2)
wrdata g10sempre_20_stati$d v(xls.xs) v(xlp.xs) v(dep) v(ina) v(vplus) v(vminus) v(main_a)
destroy all
echo "g10mai_20,g10mai_20.dat,rif,20,3.818,10,100k,1.0,8.5,36.5,1e-05,rif_mai,-,-,0.0,0," >> tb_v2_casopeggiore_manifest.csv
echo "g10sempre_20,g10sempre_20.dat,rif,20,3.818,10,100k,1.0,8.5,36.5,1e-05,rif_sempre,-,-,0.0,0," >> tb_v2_casopeggiore_manifest.csv
alter vamp dc = 3.818
alter vfrq dc = 20
alter rldm = 100k
alter rld1 = 100k
alter rld2 = 100k
alter vti dc = 1000
alter vtr dc = 2000
alter vtijk dc = 1000
alter vtrjk dc = 2000
alter vosa dc = 0
alter vosb dc = 0
alter vosf1 dc = 0
alter vosf2 dc = 0
alter ratth = 1m
alter rattb = 10k
alter rl1 = 845
alter cwire = 100p
alter vk1i dc = 0
alter vk1t dc = 1000.000000
alter vk5i dc = 0
alter vk5t dc = 1000.000000
alter vt1ri dc = 1
alter vt1rt dc = 1000.000000
alter vt1si dc = 0
alter vt1st dc = 1000.000000
alter vt2ri dc = 1
alter vt2rt dc = 1000.000000
alter vt2si dc = 0
alter vt2st dc = 1000.000000
tran 1e-05 19.0 0 1e-05
wrdata g0mai_20$d v(mainjack) v(fixjack1) v(fixjack2)
wrdata g0mai_20_stati$d v(xls.xs) v(xlp.xs) v(dep) v(ina) v(vplus) v(vminus) v(main_a)
destroy all
alter vamp dc = 3.818
alter vfrq dc = 20
alter rldm = 100k
alter rld1 = 100k
alter rld2 = 100k
alter vti dc = -10
alter vtr dc = 1000
alter vtijk dc = -10
alter vtrjk dc = 1000
alter vosa dc = 0
alter vosb dc = 0
alter vosf1 dc = 0
alter vosf2 dc = 0
alter ratth = 1m
alter rattb = 10k
alter rl1 = 845
alter cwire = 100p
alter vk1i dc = 0
alter vk1t dc = 1000.000000
alter vk5i dc = 0
alter vk5t dc = 1000.000000
alter vt1ri dc = 1
alter vt1rt dc = 1000.000000
alter vt1si dc = 0
alter vt1st dc = 1000.000000
alter vt2ri dc = 1
alter vt2rt dc = 1000.000000
alter vt2si dc = 0
alter vt2st dc = 1000.000000
tran 1e-05 19.0 0 1e-05
wrdata g0sempre_20$d v(mainjack) v(fixjack1) v(fixjack2)
wrdata g0sempre_20_stati$d v(xls.xs) v(xlp.xs) v(dep) v(ina) v(vplus) v(vminus) v(main_a)
destroy all
echo "g0mai_20,g0mai_20.dat,rif,20,3.818,0,100k,1.0,8.5,19.0,1e-05,rif_mai,-,-,0.0,0," >> tb_v2_casopeggiore_manifest.csv
echo "g0sempre_20,g0sempre_20.dat,rif,20,3.818,0,100k,1.0,8.5,19.0,1e-05,rif_sempre,-,-,0.0,0," >> tb_v2_casopeggiore_manifest.csv
alter vamp dc = 3.818
alter vfrq dc = 20
alter rldm = 100k
alter rld1 = 100k
alter rld2 = 100k
alter vti dc = 1000
alter vtr dc = 2000
alter vtijk dc = 1000
alter vtrjk dc = 2000
alter vosa dc = 0
alter vosb dc = 0
alter vosf1 dc = 0
alter vosf2 dc = 0
alter ratth = 1m
alter rattb = 10k
alter rl1 = 845
alter cwire = 100p
alter vk1i dc = 1
alter vk1t dc = 1000.000000
alter vk5i dc = 0
alter vk5t dc = 1000.000000
alter vt1ri dc = 1
alter vt1rt dc = 1000.000000
alter vt1si dc = 0
alter vt1st dc = 1000.000000
alter vt2ri dc = 1
alter vt2rt dc = 1000.000000
alter vt2si dc = 0
alter vt2st dc = 1000.000000
tran 1e-05 19.0 0 1e-05
wrdata g3mai_20$d v(mainjack) v(fixjack1) v(fixjack2)
wrdata g3mai_20_stati$d v(xls.xs) v(xlp.xs) v(dep) v(ina) v(vplus) v(vminus) v(main_a)
destroy all
alter vamp dc = 3.818
alter vfrq dc = 20
alter rldm = 100k
alter rld1 = 100k
alter rld2 = 100k
alter vti dc = -10
alter vtr dc = 1000
alter vtijk dc = -10
alter vtrjk dc = 1000
alter vosa dc = 0
alter vosb dc = 0
alter vosf1 dc = 0
alter vosf2 dc = 0
alter ratth = 1m
alter rattb = 10k
alter rl1 = 845
alter cwire = 100p
alter vk1i dc = 1
alter vk1t dc = 1000.000000
alter vk5i dc = 0
alter vk5t dc = 1000.000000
alter vt1ri dc = 1
alter vt1rt dc = 1000.000000
alter vt1si dc = 0
alter vt1st dc = 1000.000000
alter vt2ri dc = 1
alter vt2rt dc = 1000.000000
alter vt2si dc = 0
alter vt2st dc = 1000.000000
tran 1e-05 19.0 0 1e-05
wrdata g3sempre_20$d v(mainjack) v(fixjack1) v(fixjack2)
wrdata g3sempre_20_stati$d v(xls.xs) v(xlp.xs) v(dep) v(ina) v(vplus) v(vminus) v(main_a)
destroy all
echo "g3mai_20,g3mai_20.dat,rif,20,3.818,3,100k,1.0,8.5,19.0,1e-05,rif_mai,-,-,0.0,0," >> tb_v2_casopeggiore_manifest.csv
echo "g3sempre_20,g3sempre_20.dat,rif,20,3.818,3,100k,1.0,8.5,19.0,1e-05,rif_sempre,-,-,0.0,0," >> tb_v2_casopeggiore_manifest.csv
* ---- riferimenti senza segnale ----
alter vamp dc = 0
alter vfrq dc = 1000
alter rldm = 100k
alter rld1 = 100k
alter rld2 = 100k
alter vti dc = 1000
alter vtr dc = 2000
alter vtijk dc = 1000
alter vtrjk dc = 2000
alter vosa dc = 0
alter vosb dc = 0
alter vosf1 dc = 0
alter vosf2 dc = 0
alter ratth = 1m
alter rattb = 10k
alter rl1 = 845
alter cwire = 100p
alter vk1i dc = 1
alter vk1t dc = 1000.000000
alter vk5i dc = 1
alter vk5t dc = 1000.000000
alter vt1ri dc = 1
alter vt1rt dc = 1000.000000
alter vt1si dc = 0
alter vt1st dc = 1000.000000
alter vt2ri dc = 1
alter vt2rt dc = 1000.000000
alter vt2si dc = 0
alter vt2st dc = 1000.000000
tran 1e-05 36.5 0 1e-05
wrdata g10mai_lz$d v(mainjack) v(fixjack1) v(fixjack2)
wrdata g10mai_lz_stati$d v(xls.xs) v(xlp.xs) v(dep) v(ina) v(vplus) v(vminus) v(main_a)
destroy all
alter vamp dc = 0
alter vfrq dc = 1000
alter rldm = 100k
alter rld1 = 100k
alter rld2 = 100k
alter vti dc = -10
alter vtr dc = 1000
alter vtijk dc = -10
alter vtrjk dc = 1000
alter vosa dc = 0
alter vosb dc = 0
alter vosf1 dc = 0
alter vosf2 dc = 0
alter ratth = 1m
alter rattb = 10k
alter rl1 = 845
alter cwire = 100p
alter vk1i dc = 1
alter vk1t dc = 1000.000000
alter vk5i dc = 1
alter vk5t dc = 1000.000000
alter vt1ri dc = 1
alter vt1rt dc = 1000.000000
alter vt1si dc = 0
alter vt1st dc = 1000.000000
alter vt2ri dc = 1
alter vt2rt dc = 1000.000000
alter vt2si dc = 0
alter vt2st dc = 1000.000000
tran 1e-05 36.5 0 1e-05
wrdata g10sempre_lz$d v(mainjack) v(fixjack1) v(fixjack2)
wrdata g10sempre_lz_stati$d v(xls.xs) v(xlp.xs) v(dep) v(ina) v(vplus) v(vminus) v(main_a)
destroy all
echo "g10mai_lz,g10mai_lz.dat,rif,1000,0,10,100k,1.0,8.5,36.5,1e-05,rif_mai,-,-,0.0,0," >> tb_v2_casopeggiore_manifest.csv
echo "g10sempre_lz,g10sempre_lz.dat,rif,1000,0,10,100k,1.0,8.5,36.5,1e-05,rif_sempre,-,-,0.0,0," >> tb_v2_casopeggiore_manifest.csv
alter vamp dc = 0
alter vfrq dc = 1000
alter rldm = 100k
alter rld1 = 100k
alter rld2 = 100k
alter vti dc = 1000
alter vtr dc = 2000
alter vtijk dc = 1000
alter vtrjk dc = 2000
alter vosa dc = 0
alter vosb dc = 0
alter vosf1 dc = 0
alter vosf2 dc = 0
alter ratth = 1m
alter rattb = 10k
alter rl1 = 845
alter cwire = 100p
alter vk1i dc = 0
alter vk1t dc = 1000.000000
alter vk5i dc = 0
alter vk5t dc = 1000.000000
alter vt1ri dc = 1
alter vt1rt dc = 1000.000000
alter vt1si dc = 0
alter vt1st dc = 1000.000000
alter vt2ri dc = 1
alter vt2rt dc = 1000.000000
alter vt2si dc = 0
alter vt2st dc = 1000.000000
tran 1e-05 19.0 0 1e-05
wrdata g0mai_lz$d v(mainjack) v(fixjack1) v(fixjack2)
wrdata g0mai_lz_stati$d v(xls.xs) v(xlp.xs) v(dep) v(ina) v(vplus) v(vminus) v(main_a)
destroy all
alter vamp dc = 0
alter vfrq dc = 1000
alter rldm = 100k
alter rld1 = 100k
alter rld2 = 100k
alter vti dc = -10
alter vtr dc = 1000
alter vtijk dc = -10
alter vtrjk dc = 1000
alter vosa dc = 0
alter vosb dc = 0
alter vosf1 dc = 0
alter vosf2 dc = 0
alter ratth = 1m
alter rattb = 10k
alter rl1 = 845
alter cwire = 100p
alter vk1i dc = 0
alter vk1t dc = 1000.000000
alter vk5i dc = 0
alter vk5t dc = 1000.000000
alter vt1ri dc = 1
alter vt1rt dc = 1000.000000
alter vt1si dc = 0
alter vt1st dc = 1000.000000
alter vt2ri dc = 1
alter vt2rt dc = 1000.000000
alter vt2si dc = 0
alter vt2st dc = 1000.000000
tran 1e-05 19.0 0 1e-05
wrdata g0sempre_lz$d v(mainjack) v(fixjack1) v(fixjack2)
wrdata g0sempre_lz_stati$d v(xls.xs) v(xlp.xs) v(dep) v(ina) v(vplus) v(vminus) v(main_a)
destroy all
echo "g0mai_lz,g0mai_lz.dat,rif,1000,0,0,100k,1.0,8.5,19.0,1e-05,rif_mai,-,-,0.0,0," >> tb_v2_casopeggiore_manifest.csv
echo "g0sempre_lz,g0sempre_lz.dat,rif,1000,0,0,100k,1.0,8.5,19.0,1e-05,rif_sempre,-,-,0.0,0," >> tb_v2_casopeggiore_manifest.csv
alter vamp dc = 0
alter vfrq dc = 1000
alter rldm = 100k
alter rld1 = 100k
alter rld2 = 100k
alter vti dc = 1000
alter vtr dc = 2000
alter vtijk dc = 1000
alter vtrjk dc = 2000
alter vosa dc = 0
alter vosb dc = 0
alter vosf1 dc = 0
alter vosf2 dc = 0
alter ratth = 1m
alter rattb = 10k
alter rl1 = 845
alter cwire = 100p
alter vk1i dc = 1
alter vk1t dc = 1000.000000
alter vk5i dc = 0
alter vk5t dc = 1000.000000
alter vt1ri dc = 1
alter vt1rt dc = 1000.000000
alter vt1si dc = 0
alter vt1st dc = 1000.000000
alter vt2ri dc = 1
alter vt2rt dc = 1000.000000
alter vt2si dc = 0
alter vt2st dc = 1000.000000
tran 1e-05 19.0 0 1e-05
wrdata g3mai_lz$d v(mainjack) v(fixjack1) v(fixjack2)
wrdata g3mai_lz_stati$d v(xls.xs) v(xlp.xs) v(dep) v(ina) v(vplus) v(vminus) v(main_a)
destroy all
alter vamp dc = 0
alter vfrq dc = 1000
alter rldm = 100k
alter rld1 = 100k
alter rld2 = 100k
alter vti dc = -10
alter vtr dc = 1000
alter vtijk dc = -10
alter vtrjk dc = 1000
alter vosa dc = 0
alter vosb dc = 0
alter vosf1 dc = 0
alter vosf2 dc = 0
alter ratth = 1m
alter rattb = 10k
alter rl1 = 845
alter cwire = 100p
alter vk1i dc = 1
alter vk1t dc = 1000.000000
alter vk5i dc = 0
alter vk5t dc = 1000.000000
alter vt1ri dc = 1
alter vt1rt dc = 1000.000000
alter vt1si dc = 0
alter vt1st dc = 1000.000000
alter vt2ri dc = 1
alter vt2rt dc = 1000.000000
alter vt2si dc = 0
alter vt2st dc = 1000.000000
tran 1e-05 19.0 0 1e-05
wrdata g3sempre_lz$d v(mainjack) v(fixjack1) v(fixjack2)
wrdata g3sempre_lz_stati$d v(xls.xs) v(xlp.xs) v(dep) v(ina) v(vplus) v(vminus) v(main_a)
destroy all
echo "g3mai_lz,g3mai_lz.dat,rif,1000,0,3,100k,1.0,8.5,19.0,1e-05,rif_mai,-,-,0.0,0," >> tb_v2_casopeggiore_manifest.csv
echo "g3sempre_lz,g3sempre_lz.dat,rif,1000,0,3,100k,1.0,8.5,19.0,1e-05,rif_sempre,-,-,0.0,0," >> tb_v2_casopeggiore_manifest.csv
alter vamp dc = 3.818
alter vfrq dc = 1000
alter rldm = 100k
alter rld1 = 100k
alter rld2 = 100k
alter vti dc = 1000
alter vtr dc = 2000
alter vtijk dc = 1000
alter vtrjk dc = 2000
alter vosa dc = 0
alter vosb dc = 0
alter vosf1 dc = 0
alter vosf2 dc = 0
alter ratth = 1m
alter rattb = 10k
alter rl1 = 845
alter cwire = 100p
alter vk1i dc = 1
alter vk1t dc = 1000.000000
alter vk5i dc = 1
alter vk5t dc = 1000.000000
alter vt1ri dc = 0
alter vt1rt dc = 1000.000000
alter vt1si dc = 1
alter vt1st dc = 1000.000000
alter vt2ri dc = 1
alter vt2rt dc = 1000.000000
alter vt2si dc = 0
alter vt2st dc = 1000.000000
tran 1e-05 19.0 0 1e-05
wrdata t6mai_1k$d v(mainjack) v(fixjack1) v(fixjack2)
wrdata t6mai_1k_stati$d v(xls.xs) v(xlp.xs) v(dep) v(ina) v(vplus) v(vminus) v(main_a)
destroy all
alter vamp dc = 3.818
alter vfrq dc = 1000
alter rldm = 100k
alter rld1 = 100k
alter rld2 = 100k
alter vti dc = -10
alter vtr dc = 1000
alter vtijk dc = -10
alter vtrjk dc = 1000
alter vosa dc = 0
alter vosb dc = 0
alter vosf1 dc = 0
alter vosf2 dc = 0
alter ratth = 1m
alter rattb = 10k
alter rl1 = 845
alter cwire = 100p
alter vk1i dc = 1
alter vk1t dc = 1000.000000
alter vk5i dc = 1
alter vk5t dc = 1000.000000
alter vt1ri dc = 0
alter vt1rt dc = 1000.000000
alter vt1si dc = 1
alter vt1st dc = 1000.000000
alter vt2ri dc = 1
alter vt2rt dc = 1000.000000
alter vt2si dc = 0
alter vt2st dc = 1000.000000
tran 1e-05 19.0 0 1e-05
wrdata t6sempre_1k$d v(mainjack) v(fixjack1) v(fixjack2)
wrdata t6sempre_1k_stati$d v(xls.xs) v(xlp.xs) v(dep) v(ina) v(vplus) v(vminus) v(main_a)
destroy all
echo "t6mai_1k,t6mai_1k.dat,rif,1000,3.818,10,100k,1.0,8.5,19.0,1e-05,rif_mai,-,-,0.0,0," >> tb_v2_casopeggiore_manifest.csv
echo "t6sempre_1k,t6sempre_1k.dat,rif,1000,3.818,10,100k,1.0,8.5,19.0,1e-05,rif_sempre,-,-,0.0,0," >> tb_v2_casopeggiore_manifest.csv
alter vamp dc = 3.818
alter vfrq dc = 1000
alter rldm = 100k
alter rld1 = 100k
alter rld2 = 100k
alter vti dc = 1000
alter vtr dc = 2000
alter vtijk dc = 1000
alter vtrjk dc = 2000
alter vosa dc = 0
alter vosb dc = 0
alter vosf1 dc = 0
alter vosf2 dc = 0
alter ratth = 1m
alter rattb = 10k
alter rl1 = 845
alter cwire = 100p
alter vk1i dc = 1
alter vk1t dc = 1000.000000
alter vk5i dc = 1
alter vk5t dc = 1000.000000
alter vt1ri dc = 0
alter vt1rt dc = 1000.000000
alter vt1si dc = 1
alter vt1st dc = 1000.000000
alter vt2ri dc = 0
alter vt2rt dc = 1000.000000
alter vt2si dc = 1
alter vt2st dc = 1000.000000
tran 1e-05 19.0 0 1e-05
wrdata t12mai_1k$d v(mainjack) v(fixjack1) v(fixjack2)
wrdata t12mai_1k_stati$d v(xls.xs) v(xlp.xs) v(dep) v(ina) v(vplus) v(vminus) v(main_a)
destroy all
alter vamp dc = 3.818
alter vfrq dc = 1000
alter rldm = 100k
alter rld1 = 100k
alter rld2 = 100k
alter vti dc = -10
alter vtr dc = 1000
alter vtijk dc = -10
alter vtrjk dc = 1000
alter vosa dc = 0
alter vosb dc = 0
alter vosf1 dc = 0
alter vosf2 dc = 0
alter ratth = 1m
alter rattb = 10k
alter rl1 = 845
alter cwire = 100p
alter vk1i dc = 1
alter vk1t dc = 1000.000000
alter vk5i dc = 1
alter vk5t dc = 1000.000000
alter vt1ri dc = 0
alter vt1rt dc = 1000.000000
alter vt1si dc = 1
alter vt1st dc = 1000.000000
alter vt2ri dc = 0
alter vt2rt dc = 1000.000000
alter vt2si dc = 1
alter vt2st dc = 1000.000000
tran 1e-05 19.0 0 1e-05
wrdata t12sempre_1k$d v(mainjack) v(fixjack1) v(fixjack2)
wrdata t12sempre_1k_stati$d v(xls.xs) v(xlp.xs) v(dep) v(ina) v(vplus) v(vminus) v(main_a)
destroy all
echo "t12mai_1k,t12mai_1k.dat,rif,1000,3.818,10,100k,1.0,8.5,19.0,1e-05,rif_mai,-,-,0.0,0," >> tb_v2_casopeggiore_manifest.csv
echo "t12sempre_1k,t12sempre_1k.dat,rif,1000,3.818,10,100k,1.0,8.5,19.0,1e-05,rif_sempre,-,-,0.0,0," >> tb_v2_casopeggiore_manifest.csv
alter vamp dc = 0
alter vfrq dc = 1000
alter rldm = 100k
alter rld1 = 100k
alter rld2 = 100k
alter vti dc = 1000
alter vtr dc = 2000
alter vtijk dc = 1000
alter vtrjk dc = 2000
alter vosa dc = 0
alter vosb dc = 0
alter vosf1 dc = 0
alter vosf2 dc = 0
alter ratth = 1m
alter rattb = 10k
alter rl1 = 845
alter cwire = 100p
alter vk1i dc = 1
alter vk1t dc = 1000.000000
alter vk5i dc = 1
alter vk5t dc = 1000.000000
alter vt1ri dc = 0
alter vt1rt dc = 1000.000000
alter vt1si dc = 1
alter vt1st dc = 1000.000000
alter vt2ri dc = 1
alter vt2rt dc = 1000.000000
alter vt2si dc = 0
alter vt2st dc = 1000.000000
tran 1e-05 19.0 0 1e-05
wrdata t6mai_lz$d v(mainjack) v(fixjack1) v(fixjack2)
wrdata t6mai_lz_stati$d v(xls.xs) v(xlp.xs) v(dep) v(ina) v(vplus) v(vminus) v(main_a)
destroy all
alter vamp dc = 0
alter vfrq dc = 1000
alter rldm = 100k
alter rld1 = 100k
alter rld2 = 100k
alter vti dc = -10
alter vtr dc = 1000
alter vtijk dc = -10
alter vtrjk dc = 1000
alter vosa dc = 0
alter vosb dc = 0
alter vosf1 dc = 0
alter vosf2 dc = 0
alter ratth = 1m
alter rattb = 10k
alter rl1 = 845
alter cwire = 100p
alter vk1i dc = 1
alter vk1t dc = 1000.000000
alter vk5i dc = 1
alter vk5t dc = 1000.000000
alter vt1ri dc = 0
alter vt1rt dc = 1000.000000
alter vt1si dc = 1
alter vt1st dc = 1000.000000
alter vt2ri dc = 1
alter vt2rt dc = 1000.000000
alter vt2si dc = 0
alter vt2st dc = 1000.000000
tran 1e-05 19.0 0 1e-05
wrdata t6sempre_lz$d v(mainjack) v(fixjack1) v(fixjack2)
wrdata t6sempre_lz_stati$d v(xls.xs) v(xlp.xs) v(dep) v(ina) v(vplus) v(vminus) v(main_a)
destroy all
echo "t6mai_lz,t6mai_lz.dat,rif,1000,0,10,100k,1.0,8.5,19.0,1e-05,rif_mai,-,-,0.0,0," >> tb_v2_casopeggiore_manifest.csv
echo "t6sempre_lz,t6sempre_lz.dat,rif,1000,0,10,100k,1.0,8.5,19.0,1e-05,rif_sempre,-,-,0.0,0," >> tb_v2_casopeggiore_manifest.csv
alter vamp dc = 0
alter vfrq dc = 1000
alter rldm = 100k
alter rld1 = 100k
alter rld2 = 100k
alter vti dc = 1000
alter vtr dc = 2000
alter vtijk dc = 1000
alter vtrjk dc = 2000
alter vosa dc = 0
alter vosb dc = 0
alter vosf1 dc = 0
alter vosf2 dc = 0
alter ratth = 1m
alter rattb = 10k
alter rl1 = 845
alter cwire = 100p
alter vk1i dc = 1
alter vk1t dc = 1000.000000
alter vk5i dc = 1
alter vk5t dc = 1000.000000
alter vt1ri dc = 0
alter vt1rt dc = 1000.000000
alter vt1si dc = 1
alter vt1st dc = 1000.000000
alter vt2ri dc = 0
alter vt2rt dc = 1000.000000
alter vt2si dc = 1
alter vt2st dc = 1000.000000
tran 1e-05 19.0 0 1e-05
wrdata t12mai_lz$d v(mainjack) v(fixjack1) v(fixjack2)
wrdata t12mai_lz_stati$d v(xls.xs) v(xlp.xs) v(dep) v(ina) v(vplus) v(vminus) v(main_a)
destroy all
alter vamp dc = 0
alter vfrq dc = 1000
alter rldm = 100k
alter rld1 = 100k
alter rld2 = 100k
alter vti dc = -10
alter vtr dc = 1000
alter vtijk dc = -10
alter vtrjk dc = 1000
alter vosa dc = 0
alter vosb dc = 0
alter vosf1 dc = 0
alter vosf2 dc = 0
alter ratth = 1m
alter rattb = 10k
alter rl1 = 845
alter cwire = 100p
alter vk1i dc = 1
alter vk1t dc = 1000.000000
alter vk5i dc = 1
alter vk5t dc = 1000.000000
alter vt1ri dc = 0
alter vt1rt dc = 1000.000000
alter vt1si dc = 1
alter vt1st dc = 1000.000000
alter vt2ri dc = 0
alter vt2rt dc = 1000.000000
alter vt2si dc = 1
alter vt2st dc = 1000.000000
tran 1e-05 19.0 0 1e-05
wrdata t12sempre_lz$d v(mainjack) v(fixjack1) v(fixjack2)
wrdata t12sempre_lz_stati$d v(xls.xs) v(xlp.xs) v(dep) v(ina) v(vplus) v(vminus) v(main_a)
destroy all
echo "t12mai_lz,t12mai_lz.dat,rif,1000,0,10,100k,1.0,8.5,19.0,1e-05,rif_mai,-,-,0.0,0," >> tb_v2_casopeggiore_manifest.csv
echo "t12sempre_lz,t12sempre_lz.dat,rif,1000,0,10,100k,1.0,8.5,19.0,1e-05,rif_sempre,-,-,0.0,0," >> tb_v2_casopeggiore_manifest.csv
* ---- 20 kHz ----
alter vamp dc = 3.818
alter vfrq dc = 20000
alter rldm = 100k
alter rld1 = 100k
alter rld2 = 100k
alter vti dc = 1000
alter vtr dc = 2000
alter vtijk dc = 1000
alter vtrjk dc = 2000
alter vosa dc = 0
alter vosb dc = 0
alter vosf1 dc = 0
alter vosf2 dc = 0
alter ratth = 1m
alter rattb = 10k
alter rl1 = 845
alter cwire = 100p
alter vk1i dc = 1
alter vk1t dc = 1000.000000
alter vk5i dc = 1
alter vk5t dc = 1000.000000
alter vt1ri dc = 1
alter vt1rt dc = 1000.000000
alter vt1si dc = 0
alter vt1st dc = 1000.000000
alter vt2ri dc = 1
alter vt2rt dc = 1000.000000
alter vt2si dc = 0
alter vt2st dc = 1000.000000
tran 5e-07 19.0 0 5e-07
wrdata g10mai_20k$d v(mainjack) v(fixjack1) v(fixjack2)
wrdata g10mai_20k_stati$d v(xls.xs) v(xlp.xs) v(dep) v(ina) v(vplus) v(vminus) v(main_a)
destroy all
echo "g10mai_20k,g10mai_20k.dat,rif,20000,3.818,10,100k,1.0,8.5,19.0,5e-07,rif_mai,-,-,0.0,0," >> tb_v2_casopeggiore_manifest.csv
* ---- 1: 0 -> 3 dB sotto mute, 1k ----
alter vamp dc = 3.818
alter vfrq dc = 1000
alter rldm = 100k
alter rld1 = 100k
alter rld2 = 100k
alter vti dc = 1.0
alter vtr dc = 10.0
alter vtijk dc = 7.5
alter vtrjk dc = 10.0
alter vosa dc = 0
alter vosb dc = 0
alter vosf1 dc = 0
alter vosf2 dc = 0
alter ratth = 1m
alter rattb = 10k
alter rl1 = 845
alter cwire = 100p
alter vk1i dc = 0
alter vk1t dc = 8.000000
alter vk5i dc = 0
alter vk5t dc = 1000.000000
alter vt1ri dc = 1
alter vt1rt dc = 1000.000000
alter vt1si dc = 0
alter vt1st dc = 1000.000000
alter vt2ri dc = 1
alter vt2rt dc = 1000.000000
alter vt2si dc = 0
alter vt2st dc = 1000.000000
tran 1e-05 19.0 0 1e-05
wrdata gm0x3_1k$d v(mainjack) v(fixjack1) v(fixjack2)
wrdata gm0x3_1k_stati$d v(xls.xs) v(xlp.xs) v(dep) v(ina) v(vplus) v(vminus) v(main_a)
destroy all
echo "gm0x3_1k_i,gm0x3_1k.dat,ldr_v4_td6_BB,1000,3.818,0a3,100k,1.0,8.0,19.0,1e-05,evento,g0sempre_1k,g0mai_1k,6.5,1,S_ins;B2" >> tb_v2_casopeggiore_manifest.csv
echo "gm0x3_1k_c,gm0x3_1k.dat,ldr_v4_td6_BB,1000,3.818,0a3,100k,8.0,10.0,19.0,1e-05,evento,g3sempre_1k,g3mai_1k,0.0,1,S_rel;B2" >> tb_v2_casopeggiore_manifest.csv
* ---- 1: 3 -> 0 dB sotto mute, 1k ----
alter vamp dc = 3.818
alter vfrq dc = 1000
alter rldm = 100k
alter rld1 = 100k
alter rld2 = 100k
alter vti dc = 1.0
alter vtr dc = 10.0
alter vtijk dc = 7.5
alter vtrjk dc = 10.0
alter vosa dc = 0
alter vosb dc = 0
alter vosf1 dc = 0
alter vosf2 dc = 0
alter ratth = 1m
alter rattb = 10k
alter rl1 = 845
alter cwire = 100p
alter vk1i dc = 1
alter vk1t dc = 8.000000
alter vk5i dc = 0
alter vk5t dc = 1000.000000
alter vt1ri dc = 1
alter vt1rt dc = 1000.000000
alter vt1si dc = 0
alter vt1st dc = 1000.000000
alter vt2ri dc = 1
alter vt2rt dc = 1000.000000
alter vt2si dc = 0
alter vt2st dc = 1000.000000
tran 1e-05 19.0 0 1e-05
wrdata gm3x0_1k$d v(mainjack) v(fixjack1) v(fixjack2)
wrdata gm3x0_1k_stati$d v(xls.xs) v(xlp.xs) v(dep) v(ina) v(vplus) v(vminus) v(main_a)
destroy all
echo "gm3x0_1k_i,gm3x0_1k.dat,ldr_v4_td6_BB,1000,3.818,3a0,100k,1.0,8.0,19.0,1e-05,evento,g3sempre_1k,g3mai_1k,6.5,1,S_ins;B2" >> tb_v2_casopeggiore_manifest.csv
echo "gm3x0_1k_c,gm3x0_1k.dat,ldr_v4_td6_BB,1000,3.818,3a0,100k,8.0,10.0,19.0,1e-05,evento,g0sempre_1k,g0mai_1k,0.0,1,S_rel;B2" >> tb_v2_casopeggiore_manifest.csv
* ---- 1: 3 -> 10 dB sotto mute, 1k ----
alter vamp dc = 3.818
alter vfrq dc = 1000
alter rldm = 100k
alter rld1 = 100k
alter rld2 = 100k
alter vti dc = 1.0
alter vtr dc = 10.0
alter vtijk dc = 7.5
alter vtrjk dc = 10.0
alter vosa dc = 0
alter vosb dc = 0
alter vosf1 dc = 0
alter vosf2 dc = 0
alter ratth = 1m
alter rattb = 10k
alter rl1 = 845
alter cwire = 100p
alter vk1i dc = 1
alter vk1t dc = 1000.000000
alter vk5i dc = 0
alter vk5t dc = 8.000000
alter vt1ri dc = 1
alter vt1rt dc = 1000.000000
alter vt1si dc = 0
alter vt1st dc = 1000.000000
alter vt2ri dc = 1
alter vt2rt dc = 1000.000000
alter vt2si dc = 0
alter vt2st dc = 1000.000000
tran 1e-05 19.0 0 1e-05
wrdata gm3x10_1k$d v(mainjack) v(fixjack1) v(fixjack2)
wrdata gm3x10_1k_stati$d v(xls.xs) v(xlp.xs) v(dep) v(ina) v(vplus) v(vminus) v(main_a)
destroy all
echo "gm3x10_1k_i,gm3x10_1k.dat,ldr_v4_td6_BB,1000,3.818,3a10,100k,1.0,8.0,19.0,1e-05,evento,g3sempre_1k,g3mai_1k,6.5,1,S_ins;B2" >> tb_v2_casopeggiore_manifest.csv
echo "gm3x10_1k_c,gm3x10_1k.dat,ldr_v4_td6_BB,1000,3.818,3a10,100k,8.0,10.0,19.0,1e-05,evento,g10sempre_1k,g10mai_1k,0.0,1,S_rel;B2" >> tb_v2_casopeggiore_manifest.csv
* ---- 1: 10 -> 3 dB sotto mute, 1k ----
alter vamp dc = 3.818
alter vfrq dc = 1000
alter rldm = 100k
alter rld1 = 100k
alter rld2 = 100k
alter vti dc = 1.0
alter vtr dc = 10.0
alter vtijk dc = 7.5
alter vtrjk dc = 10.0
alter vosa dc = 0
alter vosb dc = 0
alter vosf1 dc = 0
alter vosf2 dc = 0
alter ratth = 1m
alter rattb = 10k
alter rl1 = 845
alter cwire = 100p
alter vk1i dc = 1
alter vk1t dc = 1000.000000
alter vk5i dc = 1
alter vk5t dc = 8.000000
alter vt1ri dc = 1
alter vt1rt dc = 1000.000000
alter vt1si dc = 0
alter vt1st dc = 1000.000000
alter vt2ri dc = 1
alter vt2rt dc = 1000.000000
alter vt2si dc = 0
alter vt2st dc = 1000.000000
tran 1e-05 19.0 0 1e-05
wrdata gm10x3_1k$d v(mainjack) v(fixjack1) v(fixjack2)
wrdata gm10x3_1k_stati$d v(xls.xs) v(xlp.xs) v(dep) v(ina) v(vplus) v(vminus) v(main_a)
destroy all
echo "gm10x3_1k_i,gm10x3_1k.dat,ldr_v4_td6_BB,1000,3.818,10a3,100k,1.0,8.0,19.0,1e-05,evento,g10sempre_1k,g10mai_1k,6.5,1,S_ins;B2" >> tb_v2_casopeggiore_manifest.csv
echo "gm10x3_1k_c,gm10x3_1k.dat,ldr_v4_td6_BB,1000,3.818,10a3,100k,8.0,10.0,19.0,1e-05,evento,g3sempre_1k,g3mai_1k,0.0,1,S_rel;B2" >> tb_v2_casopeggiore_manifest.csv
* ---- 1: 0 -> 10 dB sotto mute, 1k ----
alter vamp dc = 3.818
alter vfrq dc = 1000
alter rldm = 100k
alter rld1 = 100k
alter rld2 = 100k
alter vti dc = 1.0
alter vtr dc = 10.0
alter vtijk dc = 7.5
alter vtrjk dc = 10.0
alter vosa dc = 0
alter vosb dc = 0
alter vosf1 dc = 0
alter vosf2 dc = 0
alter ratth = 1m
alter rattb = 10k
alter rl1 = 845
alter cwire = 100p
alter vk1i dc = 0
alter vk1t dc = 8.000300
alter vk5i dc = 0
alter vk5t dc = 8.000000
alter vt1ri dc = 1
alter vt1rt dc = 1000.000000
alter vt1si dc = 0
alter vt1st dc = 1000.000000
alter vt2ri dc = 1
alter vt2rt dc = 1000.000000
alter vt2si dc = 0
alter vt2st dc = 1000.000000
tran 1e-05 19.0 0 1e-05
wrdata gm0x10_1k$d v(mainjack) v(fixjack1) v(fixjack2)
wrdata gm0x10_1k_stati$d v(xls.xs) v(xlp.xs) v(dep) v(ina) v(vplus) v(vminus) v(main_a)
destroy all
echo "gm0x10_1k_i,gm0x10_1k.dat,ldr_v4_td6_BB,1000,3.818,0a10,100k,1.0,8.0,19.0,1e-05,evento,g0sempre_1k,g0mai_1k,6.5,1,S_ins;B2" >> tb_v2_casopeggiore_manifest.csv
echo "gm0x10_1k_c,gm0x10_1k.dat,ldr_v4_td6_BB,1000,3.818,0a10,100k,8.0,10.0,19.0,1e-05,evento,g10sempre_1k,g10mai_1k,0.0,1,S_rel;B2" >> tb_v2_casopeggiore_manifest.csv
* ---- 1: 10 -> 0 dB sotto mute, 1k ----
alter vamp dc = 3.818
alter vfrq dc = 1000
alter rldm = 100k
alter rld1 = 100k
alter rld2 = 100k
alter vti dc = 1.0
alter vtr dc = 10.0
alter vtijk dc = 7.5
alter vtrjk dc = 10.0
alter vosa dc = 0
alter vosb dc = 0
alter vosf1 dc = 0
alter vosf2 dc = 0
alter ratth = 1m
alter rattb = 10k
alter rl1 = 845
alter cwire = 100p
alter vk1i dc = 1
alter vk1t dc = 8.000000
alter vk5i dc = 1
alter vk5t dc = 8.000300
alter vt1ri dc = 1
alter vt1rt dc = 1000.000000
alter vt1si dc = 0
alter vt1st dc = 1000.000000
alter vt2ri dc = 1
alter vt2rt dc = 1000.000000
alter vt2si dc = 0
alter vt2st dc = 1000.000000
tran 1e-05 19.0 0 1e-05
wrdata gm10x0_1k$d v(mainjack) v(fixjack1) v(fixjack2)
wrdata gm10x0_1k_stati$d v(xls.xs) v(xlp.xs) v(dep) v(ina) v(vplus) v(vminus) v(main_a)
destroy all
echo "gm10x0_1k_i,gm10x0_1k.dat,ldr_v4_td6_BB,1000,3.818,10a0,100k,1.0,8.0,19.0,1e-05,evento,g10sempre_1k,g10mai_1k,6.5,1,S_ins;B2" >> tb_v2_casopeggiore_manifest.csv
echo "gm10x0_1k_c,gm10x0_1k.dat,ldr_v4_td6_BB,1000,3.818,10a0,100k,8.0,10.0,19.0,1e-05,evento,g0sempre_1k,g0mai_1k,0.0,1,S_rel;B2" >> tb_v2_casopeggiore_manifest.csv
* ---- 1: 0 -> 3 dB sotto mute, 20 ----
alter vamp dc = 3.818
alter vfrq dc = 20
alter rldm = 100k
alter rld1 = 100k
alter rld2 = 100k
alter vti dc = 1.0
alter vtr dc = 10.0
alter vtijk dc = 7.5
alter vtrjk dc = 10.0
alter vosa dc = 0
alter vosb dc = 0
alter vosf1 dc = 0
alter vosf2 dc = 0
alter ratth = 1m
alter rattb = 10k
alter rl1 = 845
alter cwire = 100p
alter vk1i dc = 0
alter vk1t dc = 8.000000
alter vk5i dc = 0
alter vk5t dc = 1000.000000
alter vt1ri dc = 1
alter vt1rt dc = 1000.000000
alter vt1si dc = 0
alter vt1st dc = 1000.000000
alter vt2ri dc = 1
alter vt2rt dc = 1000.000000
alter vt2si dc = 0
alter vt2st dc = 1000.000000
tran 1e-05 19.0 0 1e-05
wrdata gm0x3_20$d v(mainjack) v(fixjack1) v(fixjack2)
wrdata gm0x3_20_stati$d v(xls.xs) v(xlp.xs) v(dep) v(ina) v(vplus) v(vminus) v(main_a)
destroy all
echo "gm0x3_20_i,gm0x3_20.dat,ldr_v4_td6_BB,20,3.818,0a3,100k,1.0,8.0,19.0,1e-05,evento,g0sempre_20,g0mai_20,6.5,1,S_ins;B2" >> tb_v2_casopeggiore_manifest.csv
echo "gm0x3_20_c,gm0x3_20.dat,ldr_v4_td6_BB,20,3.818,0a3,100k,8.0,10.0,19.0,1e-05,evento,g3sempre_20,g3mai_20,0.0,1,S_rel;B2" >> tb_v2_casopeggiore_manifest.csv
* ---- 1: 3 -> 0 dB sotto mute, 20 ----
alter vamp dc = 3.818
alter vfrq dc = 20
alter rldm = 100k
alter rld1 = 100k
alter rld2 = 100k
alter vti dc = 1.0
alter vtr dc = 10.0
alter vtijk dc = 7.5
alter vtrjk dc = 10.0
alter vosa dc = 0
alter vosb dc = 0
alter vosf1 dc = 0
alter vosf2 dc = 0
alter ratth = 1m
alter rattb = 10k
alter rl1 = 845
alter cwire = 100p
alter vk1i dc = 1
alter vk1t dc = 8.000000
alter vk5i dc = 0
alter vk5t dc = 1000.000000
alter vt1ri dc = 1
alter vt1rt dc = 1000.000000
alter vt1si dc = 0
alter vt1st dc = 1000.000000
alter vt2ri dc = 1
alter vt2rt dc = 1000.000000
alter vt2si dc = 0
alter vt2st dc = 1000.000000
tran 1e-05 19.0 0 1e-05
wrdata gm3x0_20$d v(mainjack) v(fixjack1) v(fixjack2)
wrdata gm3x0_20_stati$d v(xls.xs) v(xlp.xs) v(dep) v(ina) v(vplus) v(vminus) v(main_a)
destroy all
echo "gm3x0_20_i,gm3x0_20.dat,ldr_v4_td6_BB,20,3.818,3a0,100k,1.0,8.0,19.0,1e-05,evento,g3sempre_20,g3mai_20,6.5,1,S_ins;B2" >> tb_v2_casopeggiore_manifest.csv
echo "gm3x0_20_c,gm3x0_20.dat,ldr_v4_td6_BB,20,3.818,3a0,100k,8.0,10.0,19.0,1e-05,evento,g0sempre_20,g0mai_20,0.0,1,S_rel;B2" >> tb_v2_casopeggiore_manifest.csv
* ---- 1: 3 -> 10 dB sotto mute, 20 ----
alter vamp dc = 3.818
alter vfrq dc = 20
alter rldm = 100k
alter rld1 = 100k
alter rld2 = 100k
alter vti dc = 1.0
alter vtr dc = 10.0
alter vtijk dc = 7.5
alter vtrjk dc = 10.0
alter vosa dc = 0
alter vosb dc = 0
alter vosf1 dc = 0
alter vosf2 dc = 0
alter ratth = 1m
alter rattb = 10k
alter rl1 = 845
alter cwire = 100p
alter vk1i dc = 1
alter vk1t dc = 1000.000000
alter vk5i dc = 0
alter vk5t dc = 8.000000
alter vt1ri dc = 1
alter vt1rt dc = 1000.000000
alter vt1si dc = 0
alter vt1st dc = 1000.000000
alter vt2ri dc = 1
alter vt2rt dc = 1000.000000
alter vt2si dc = 0
alter vt2st dc = 1000.000000
tran 1e-05 19.0 0 1e-05
wrdata gm3x10_20$d v(mainjack) v(fixjack1) v(fixjack2)
wrdata gm3x10_20_stati$d v(xls.xs) v(xlp.xs) v(dep) v(ina) v(vplus) v(vminus) v(main_a)
destroy all
echo "gm3x10_20_i,gm3x10_20.dat,ldr_v4_td6_BB,20,3.818,3a10,100k,1.0,8.0,19.0,1e-05,evento,g3sempre_20,g3mai_20,6.5,1,S_ins;B2" >> tb_v2_casopeggiore_manifest.csv
echo "gm3x10_20_c,gm3x10_20.dat,ldr_v4_td6_BB,20,3.818,3a10,100k,8.0,10.0,19.0,1e-05,evento,g10sempre_20,g10mai_20,0.0,1,S_rel;B2" >> tb_v2_casopeggiore_manifest.csv
* ---- 1: 10 -> 3 dB sotto mute, 20 ----
alter vamp dc = 3.818
alter vfrq dc = 20
alter rldm = 100k
alter rld1 = 100k
alter rld2 = 100k
alter vti dc = 1.0
alter vtr dc = 10.0
alter vtijk dc = 7.5
alter vtrjk dc = 10.0
alter vosa dc = 0
alter vosb dc = 0
alter vosf1 dc = 0
alter vosf2 dc = 0
alter ratth = 1m
alter rattb = 10k
alter rl1 = 845
alter cwire = 100p
alter vk1i dc = 1
alter vk1t dc = 1000.000000
alter vk5i dc = 1
alter vk5t dc = 8.000000
alter vt1ri dc = 1
alter vt1rt dc = 1000.000000
alter vt1si dc = 0
alter vt1st dc = 1000.000000
alter vt2ri dc = 1
alter vt2rt dc = 1000.000000
alter vt2si dc = 0
alter vt2st dc = 1000.000000
tran 1e-05 19.0 0 1e-05
wrdata gm10x3_20$d v(mainjack) v(fixjack1) v(fixjack2)
wrdata gm10x3_20_stati$d v(xls.xs) v(xlp.xs) v(dep) v(ina) v(vplus) v(vminus) v(main_a)
destroy all
echo "gm10x3_20_i,gm10x3_20.dat,ldr_v4_td6_BB,20,3.818,10a3,100k,1.0,8.0,19.0,1e-05,evento,g10sempre_20,g10mai_20,6.5,1,S_ins;B2" >> tb_v2_casopeggiore_manifest.csv
echo "gm10x3_20_c,gm10x3_20.dat,ldr_v4_td6_BB,20,3.818,10a3,100k,8.0,10.0,19.0,1e-05,evento,g3sempre_20,g3mai_20,0.0,1,S_rel;B2" >> tb_v2_casopeggiore_manifest.csv
* ---- 1: 0 -> 10 dB sotto mute, 20 ----
alter vamp dc = 3.818
alter vfrq dc = 20
alter rldm = 100k
alter rld1 = 100k
alter rld2 = 100k
alter vti dc = 1.0
alter vtr dc = 10.0
alter vtijk dc = 7.5
alter vtrjk dc = 10.0
alter vosa dc = 0
alter vosb dc = 0
alter vosf1 dc = 0
alter vosf2 dc = 0
alter ratth = 1m
alter rattb = 10k
alter rl1 = 845
alter cwire = 100p
alter vk1i dc = 0
alter vk1t dc = 8.000300
alter vk5i dc = 0
alter vk5t dc = 8.000000
alter vt1ri dc = 1
alter vt1rt dc = 1000.000000
alter vt1si dc = 0
alter vt1st dc = 1000.000000
alter vt2ri dc = 1
alter vt2rt dc = 1000.000000
alter vt2si dc = 0
alter vt2st dc = 1000.000000
tran 1e-05 19.0 0 1e-05
wrdata gm0x10_20$d v(mainjack) v(fixjack1) v(fixjack2)
wrdata gm0x10_20_stati$d v(xls.xs) v(xlp.xs) v(dep) v(ina) v(vplus) v(vminus) v(main_a)
destroy all
echo "gm0x10_20_i,gm0x10_20.dat,ldr_v4_td6_BB,20,3.818,0a10,100k,1.0,8.0,19.0,1e-05,evento,g0sempre_20,g0mai_20,6.5,1,S_ins;B2" >> tb_v2_casopeggiore_manifest.csv
echo "gm0x10_20_c,gm0x10_20.dat,ldr_v4_td6_BB,20,3.818,0a10,100k,8.0,10.0,19.0,1e-05,evento,g10sempre_20,g10mai_20,0.0,1,S_rel;B2" >> tb_v2_casopeggiore_manifest.csv
* ---- 1: 10 -> 0 dB sotto mute, 20 ----
alter vamp dc = 3.818
alter vfrq dc = 20
alter rldm = 100k
alter rld1 = 100k
alter rld2 = 100k
alter vti dc = 1.0
alter vtr dc = 10.0
alter vtijk dc = 7.5
alter vtrjk dc = 10.0
alter vosa dc = 0
alter vosb dc = 0
alter vosf1 dc = 0
alter vosf2 dc = 0
alter ratth = 1m
alter rattb = 10k
alter rl1 = 845
alter cwire = 100p
alter vk1i dc = 1
alter vk1t dc = 8.000000
alter vk5i dc = 1
alter vk5t dc = 8.000300
alter vt1ri dc = 1
alter vt1rt dc = 1000.000000
alter vt1si dc = 0
alter vt1st dc = 1000.000000
alter vt2ri dc = 1
alter vt2rt dc = 1000.000000
alter vt2si dc = 0
alter vt2st dc = 1000.000000
tran 1e-05 19.0 0 1e-05
wrdata gm10x0_20$d v(mainjack) v(fixjack1) v(fixjack2)
wrdata gm10x0_20_stati$d v(xls.xs) v(xlp.xs) v(dep) v(ina) v(vplus) v(vminus) v(main_a)
destroy all
echo "gm10x0_20_i,gm10x0_20.dat,ldr_v4_td6_BB,20,3.818,10a0,100k,1.0,8.0,19.0,1e-05,evento,g10sempre_20,g10mai_20,6.5,1,S_ins;B2" >> tb_v2_casopeggiore_manifest.csv
echo "gm10x0_20_c,gm10x0_20.dat,ldr_v4_td6_BB,20,3.818,10a0,100k,8.0,10.0,19.0,1e-05,evento,g0sempre_20,g0mai_20,0.0,1,S_rel;B2" >> tb_v2_casopeggiore_manifest.csv
* ---- 1: 0 -> 3 dB sotto mute, lz ----
alter vamp dc = 0
alter vfrq dc = 1000
alter rldm = 100k
alter rld1 = 100k
alter rld2 = 100k
alter vti dc = 1.0
alter vtr dc = 10.0
alter vtijk dc = 7.5
alter vtrjk dc = 10.0
alter vosa dc = 0
alter vosb dc = 0
alter vosf1 dc = 0
alter vosf2 dc = 0
alter ratth = 1m
alter rattb = 10k
alter rl1 = 845
alter cwire = 100p
alter vk1i dc = 0
alter vk1t dc = 8.000000
alter vk5i dc = 0
alter vk5t dc = 1000.000000
alter vt1ri dc = 1
alter vt1rt dc = 1000.000000
alter vt1si dc = 0
alter vt1st dc = 1000.000000
alter vt2ri dc = 1
alter vt2rt dc = 1000.000000
alter vt2si dc = 0
alter vt2st dc = 1000.000000
tran 1e-05 19.0 0 1e-05
wrdata gm0x3_lz$d v(mainjack) v(fixjack1) v(fixjack2)
wrdata gm0x3_lz_stati$d v(xls.xs) v(xlp.xs) v(dep) v(ina) v(vplus) v(vminus) v(main_a)
destroy all
echo "gm0x3_lz_i,gm0x3_lz.dat,ldr_v4_td6_BB,1000,0,0a3,100k,1.0,8.0,19.0,1e-05,evento,g0sempre_lz,g0mai_lz,6.5,1,A_ins;B2" >> tb_v2_casopeggiore_manifest.csv
echo "gm0x3_lz_c,gm0x3_lz.dat,ldr_v4_td6_BB,1000,0,0a3,100k,8.0,10.0,19.0,1e-05,evento,g3sempre_lz,g3mai_lz,0.0,1,A_ins;A_rel;B2" >> tb_v2_casopeggiore_manifest.csv
alter vamp dc = 0
alter vfrq dc = 1000
alter rldm = 100k
alter rld1 = 100k
alter rld2 = 100k
alter vti dc = 1000
alter vtr dc = 2000
alter vtijk dc = 1000
alter vtrjk dc = 2000
alter vosa dc = 0
alter vosb dc = 0
alter vosf1 dc = 0
alter vosf2 dc = 0
alter ratth = 1m
alter rattb = 10k
alter rl1 = 845
alter cwire = 100p
alter vk1i dc = 0
alter vk1t dc = 1.000000
alter vk5i dc = 0
alter vk5t dc = 1000.000000
alter vt1ri dc = 1
alter vt1rt dc = 1000.000000
alter vt1si dc = 0
alter vt1st dc = 1000.000000
alter vt2ri dc = 1
alter vt2rt dc = 1000.000000
alter vt2si dc = 0
alter vt2st dc = 1000.000000
tran 1e-05 3.5 0 1e-05
wrdata gc0x3_lz$d v(mainjack) v(fixjack1) v(fixjack2)
wrdata gc0x3_lz_stati$d v(xls.xs) v(xlp.xs) v(dep) v(ina) v(vplus) v(vminus) v(main_a)
destroy all
echo "gc0x3_lz,gc0x3_lz.dat,caldo,1000,0,0a3,100k,1.0,1000,3.5,1e-05,evento,g3mai_lz,-,0.0,1,A_ins" >> tb_v2_casopeggiore_manifest.csv
* ---- 1: 3 -> 0 dB sotto mute, lz ----
alter vamp dc = 0
alter vfrq dc = 1000
alter rldm = 100k
alter rld1 = 100k
alter rld2 = 100k
alter vti dc = 1.0
alter vtr dc = 10.0
alter vtijk dc = 7.5
alter vtrjk dc = 10.0
alter vosa dc = 0
alter vosb dc = 0
alter vosf1 dc = 0
alter vosf2 dc = 0
alter ratth = 1m
alter rattb = 10k
alter rl1 = 845
alter cwire = 100p
alter vk1i dc = 1
alter vk1t dc = 8.000000
alter vk5i dc = 0
alter vk5t dc = 1000.000000
alter vt1ri dc = 1
alter vt1rt dc = 1000.000000
alter vt1si dc = 0
alter vt1st dc = 1000.000000
alter vt2ri dc = 1
alter vt2rt dc = 1000.000000
alter vt2si dc = 0
alter vt2st dc = 1000.000000
tran 1e-05 19.0 0 1e-05
wrdata gm3x0_lz$d v(mainjack) v(fixjack1) v(fixjack2)
wrdata gm3x0_lz_stati$d v(xls.xs) v(xlp.xs) v(dep) v(ina) v(vplus) v(vminus) v(main_a)
destroy all
echo "gm3x0_lz_i,gm3x0_lz.dat,ldr_v4_td6_BB,1000,0,3a0,100k,1.0,8.0,19.0,1e-05,evento,g3sempre_lz,g3mai_lz,6.5,1,A_ins;B2" >> tb_v2_casopeggiore_manifest.csv
echo "gm3x0_lz_c,gm3x0_lz.dat,ldr_v4_td6_BB,1000,0,3a0,100k,8.0,10.0,19.0,1e-05,evento,g0sempre_lz,g0mai_lz,0.0,1,A_ins;A_rel;B2" >> tb_v2_casopeggiore_manifest.csv
alter vamp dc = 0
alter vfrq dc = 1000
alter rldm = 100k
alter rld1 = 100k
alter rld2 = 100k
alter vti dc = 1000
alter vtr dc = 2000
alter vtijk dc = 1000
alter vtrjk dc = 2000
alter vosa dc = 0
alter vosb dc = 0
alter vosf1 dc = 0
alter vosf2 dc = 0
alter ratth = 1m
alter rattb = 10k
alter rl1 = 845
alter cwire = 100p
alter vk1i dc = 1
alter vk1t dc = 1.000000
alter vk5i dc = 0
alter vk5t dc = 1000.000000
alter vt1ri dc = 1
alter vt1rt dc = 1000.000000
alter vt1si dc = 0
alter vt1st dc = 1000.000000
alter vt2ri dc = 1
alter vt2rt dc = 1000.000000
alter vt2si dc = 0
alter vt2st dc = 1000.000000
tran 1e-05 3.5 0 1e-05
wrdata gc3x0_lz$d v(mainjack) v(fixjack1) v(fixjack2)
wrdata gc3x0_lz_stati$d v(xls.xs) v(xlp.xs) v(dep) v(ina) v(vplus) v(vminus) v(main_a)
destroy all
echo "gc3x0_lz,gc3x0_lz.dat,caldo,1000,0,3a0,100k,1.0,1000,3.5,1e-05,evento,g0mai_lz,-,0.0,1,A_ins" >> tb_v2_casopeggiore_manifest.csv
* ---- 1: 3 -> 10 dB sotto mute, lz ----
alter vamp dc = 0
alter vfrq dc = 1000
alter rldm = 100k
alter rld1 = 100k
alter rld2 = 100k
alter vti dc = 1.0
alter vtr dc = 10.0
alter vtijk dc = 7.5
alter vtrjk dc = 10.0
alter vosa dc = 0
alter vosb dc = 0
alter vosf1 dc = 0
alter vosf2 dc = 0
alter ratth = 1m
alter rattb = 10k
alter rl1 = 845
alter cwire = 100p
alter vk1i dc = 1
alter vk1t dc = 1000.000000
alter vk5i dc = 0
alter vk5t dc = 8.000000
alter vt1ri dc = 1
alter vt1rt dc = 1000.000000
alter vt1si dc = 0
alter vt1st dc = 1000.000000
alter vt2ri dc = 1
alter vt2rt dc = 1000.000000
alter vt2si dc = 0
alter vt2st dc = 1000.000000
tran 1e-05 19.0 0 1e-05
wrdata gm3x10_lz$d v(mainjack) v(fixjack1) v(fixjack2)
wrdata gm3x10_lz_stati$d v(xls.xs) v(xlp.xs) v(dep) v(ina) v(vplus) v(vminus) v(main_a)
destroy all
echo "gm3x10_lz_i,gm3x10_lz.dat,ldr_v4_td6_BB,1000,0,3a10,100k,1.0,8.0,19.0,1e-05,evento,g3sempre_lz,g3mai_lz,6.5,1,A_ins;B2" >> tb_v2_casopeggiore_manifest.csv
echo "gm3x10_lz_c,gm3x10_lz.dat,ldr_v4_td6_BB,1000,0,3a10,100k,8.0,10.0,19.0,1e-05,evento,g10sempre_lz,g10mai_lz,0.0,1,A_ins;A_rel;B2" >> tb_v2_casopeggiore_manifest.csv
alter vamp dc = 0
alter vfrq dc = 1000
alter rldm = 100k
alter rld1 = 100k
alter rld2 = 100k
alter vti dc = 1000
alter vtr dc = 2000
alter vtijk dc = 1000
alter vtrjk dc = 2000
alter vosa dc = 0
alter vosb dc = 0
alter vosf1 dc = 0
alter vosf2 dc = 0
alter ratth = 1m
alter rattb = 10k
alter rl1 = 845
alter cwire = 100p
alter vk1i dc = 1
alter vk1t dc = 1000.000000
alter vk5i dc = 0
alter vk5t dc = 1.000000
alter vt1ri dc = 1
alter vt1rt dc = 1000.000000
alter vt1si dc = 0
alter vt1st dc = 1000.000000
alter vt2ri dc = 1
alter vt2rt dc = 1000.000000
alter vt2si dc = 0
alter vt2st dc = 1000.000000
tran 1e-05 3.5 0 1e-05
wrdata gc3x10_lz$d v(mainjack) v(fixjack1) v(fixjack2)
wrdata gc3x10_lz_stati$d v(xls.xs) v(xlp.xs) v(dep) v(ina) v(vplus) v(vminus) v(main_a)
destroy all
echo "gc3x10_lz,gc3x10_lz.dat,caldo,1000,0,3a10,100k,1.0,1000,3.5,1e-05,evento,g10mai_lz,-,0.0,1,A_ins" >> tb_v2_casopeggiore_manifest.csv
* ---- 1: 10 -> 3 dB sotto mute, lz ----
alter vamp dc = 0
alter vfrq dc = 1000
alter rldm = 100k
alter rld1 = 100k
alter rld2 = 100k
alter vti dc = 1.0
alter vtr dc = 10.0
alter vtijk dc = 7.5
alter vtrjk dc = 10.0
alter vosa dc = 0
alter vosb dc = 0
alter vosf1 dc = 0
alter vosf2 dc = 0
alter ratth = 1m
alter rattb = 10k
alter rl1 = 845
alter cwire = 100p
alter vk1i dc = 1
alter vk1t dc = 1000.000000
alter vk5i dc = 1
alter vk5t dc = 8.000000
alter vt1ri dc = 1
alter vt1rt dc = 1000.000000
alter vt1si dc = 0
alter vt1st dc = 1000.000000
alter vt2ri dc = 1
alter vt2rt dc = 1000.000000
alter vt2si dc = 0
alter vt2st dc = 1000.000000
tran 1e-05 19.0 0 1e-05
wrdata gm10x3_lz$d v(mainjack) v(fixjack1) v(fixjack2)
wrdata gm10x3_lz_stati$d v(xls.xs) v(xlp.xs) v(dep) v(ina) v(vplus) v(vminus) v(main_a)
destroy all
echo "gm10x3_lz_i,gm10x3_lz.dat,ldr_v4_td6_BB,1000,0,10a3,100k,1.0,8.0,19.0,1e-05,evento,g10sempre_lz,g10mai_lz,6.5,1,A_ins;B2" >> tb_v2_casopeggiore_manifest.csv
echo "gm10x3_lz_c,gm10x3_lz.dat,ldr_v4_td6_BB,1000,0,10a3,100k,8.0,10.0,19.0,1e-05,evento,g3sempre_lz,g3mai_lz,0.0,1,A_ins;A_rel;B2" >> tb_v2_casopeggiore_manifest.csv
alter vamp dc = 0
alter vfrq dc = 1000
alter rldm = 100k
alter rld1 = 100k
alter rld2 = 100k
alter vti dc = 1000
alter vtr dc = 2000
alter vtijk dc = 1000
alter vtrjk dc = 2000
alter vosa dc = 0
alter vosb dc = 0
alter vosf1 dc = 0
alter vosf2 dc = 0
alter ratth = 1m
alter rattb = 10k
alter rl1 = 845
alter cwire = 100p
alter vk1i dc = 1
alter vk1t dc = 1000.000000
alter vk5i dc = 1
alter vk5t dc = 1.000000
alter vt1ri dc = 1
alter vt1rt dc = 1000.000000
alter vt1si dc = 0
alter vt1st dc = 1000.000000
alter vt2ri dc = 1
alter vt2rt dc = 1000.000000
alter vt2si dc = 0
alter vt2st dc = 1000.000000
tran 1e-05 3.5 0 1e-05
wrdata gc10x3_lz$d v(mainjack) v(fixjack1) v(fixjack2)
wrdata gc10x3_lz_stati$d v(xls.xs) v(xlp.xs) v(dep) v(ina) v(vplus) v(vminus) v(main_a)
destroy all
echo "gc10x3_lz,gc10x3_lz.dat,caldo,1000,0,10a3,100k,1.0,1000,3.5,1e-05,evento,g3mai_lz,-,0.0,1,A_ins" >> tb_v2_casopeggiore_manifest.csv
* ---- 1: 0 -> 10 dB sotto mute, lz ----
alter vamp dc = 0
alter vfrq dc = 1000
alter rldm = 100k
alter rld1 = 100k
alter rld2 = 100k
alter vti dc = 1.0
alter vtr dc = 10.0
alter vtijk dc = 7.5
alter vtrjk dc = 10.0
alter vosa dc = 0
alter vosb dc = 0
alter vosf1 dc = 0
alter vosf2 dc = 0
alter ratth = 1m
alter rattb = 10k
alter rl1 = 845
alter cwire = 100p
alter vk1i dc = 0
alter vk1t dc = 8.000300
alter vk5i dc = 0
alter vk5t dc = 8.000000
alter vt1ri dc = 1
alter vt1rt dc = 1000.000000
alter vt1si dc = 0
alter vt1st dc = 1000.000000
alter vt2ri dc = 1
alter vt2rt dc = 1000.000000
alter vt2si dc = 0
alter vt2st dc = 1000.000000
tran 1e-05 19.0 0 1e-05
wrdata gm0x10_lz$d v(mainjack) v(fixjack1) v(fixjack2)
wrdata gm0x10_lz_stati$d v(xls.xs) v(xlp.xs) v(dep) v(ina) v(vplus) v(vminus) v(main_a)
destroy all
echo "gm0x10_lz_i,gm0x10_lz.dat,ldr_v4_td6_BB,1000,0,0a10,100k,1.0,8.0,19.0,1e-05,evento,g0sempre_lz,g0mai_lz,6.5,1,A_ins;B2" >> tb_v2_casopeggiore_manifest.csv
echo "gm0x10_lz_c,gm0x10_lz.dat,ldr_v4_td6_BB,1000,0,0a10,100k,8.0,10.0,19.0,1e-05,evento,g10sempre_lz,g10mai_lz,0.0,1,A_ins;A_rel;B2" >> tb_v2_casopeggiore_manifest.csv
alter vamp dc = 0
alter vfrq dc = 1000
alter rldm = 100k
alter rld1 = 100k
alter rld2 = 100k
alter vti dc = 1000
alter vtr dc = 2000
alter vtijk dc = 1000
alter vtrjk dc = 2000
alter vosa dc = 0
alter vosb dc = 0
alter vosf1 dc = 0
alter vosf2 dc = 0
alter ratth = 1m
alter rattb = 10k
alter rl1 = 845
alter cwire = 100p
alter vk1i dc = 0
alter vk1t dc = 1.000300
alter vk5i dc = 0
alter vk5t dc = 1.000000
alter vt1ri dc = 1
alter vt1rt dc = 1000.000000
alter vt1si dc = 0
alter vt1st dc = 1000.000000
alter vt2ri dc = 1
alter vt2rt dc = 1000.000000
alter vt2si dc = 0
alter vt2st dc = 1000.000000
tran 1e-05 3.5 0 1e-05
wrdata gc0x10_lz$d v(mainjack) v(fixjack1) v(fixjack2)
wrdata gc0x10_lz_stati$d v(xls.xs) v(xlp.xs) v(dep) v(ina) v(vplus) v(vminus) v(main_a)
destroy all
echo "gc0x10_lz,gc0x10_lz.dat,caldo,1000,0,0a10,100k,1.0,1000,3.5,1e-05,evento,g10mai_lz,-,0.0,1,A_ins" >> tb_v2_casopeggiore_manifest.csv
* ---- 1: 10 -> 0 dB sotto mute, lz ----
alter vamp dc = 0
alter vfrq dc = 1000
alter rldm = 100k
alter rld1 = 100k
alter rld2 = 100k
alter vti dc = 1.0
alter vtr dc = 10.0
alter vtijk dc = 7.5
alter vtrjk dc = 10.0
alter vosa dc = 0
alter vosb dc = 0
alter vosf1 dc = 0
alter vosf2 dc = 0
alter ratth = 1m
alter rattb = 10k
alter rl1 = 845
alter cwire = 100p
alter vk1i dc = 1
alter vk1t dc = 8.000000
alter vk5i dc = 1
alter vk5t dc = 8.000300
alter vt1ri dc = 1
alter vt1rt dc = 1000.000000
alter vt1si dc = 0
alter vt1st dc = 1000.000000
alter vt2ri dc = 1
alter vt2rt dc = 1000.000000
alter vt2si dc = 0
alter vt2st dc = 1000.000000
tran 1e-05 19.0 0 1e-05
wrdata gm10x0_lz$d v(mainjack) v(fixjack1) v(fixjack2)
wrdata gm10x0_lz_stati$d v(xls.xs) v(xlp.xs) v(dep) v(ina) v(vplus) v(vminus) v(main_a)
destroy all
echo "gm10x0_lz_i,gm10x0_lz.dat,ldr_v4_td6_BB,1000,0,10a0,100k,1.0,8.0,19.0,1e-05,evento,g10sempre_lz,g10mai_lz,6.5,1,A_ins;B2" >> tb_v2_casopeggiore_manifest.csv
echo "gm10x0_lz_c,gm10x0_lz.dat,ldr_v4_td6_BB,1000,0,10a0,100k,8.0,10.0,19.0,1e-05,evento,g0sempre_lz,g0mai_lz,0.0,1,A_ins;A_rel;B2" >> tb_v2_casopeggiore_manifest.csv
alter vamp dc = 0
alter vfrq dc = 1000
alter rldm = 100k
alter rld1 = 100k
alter rld2 = 100k
alter vti dc = 1000
alter vtr dc = 2000
alter vtijk dc = 1000
alter vtrjk dc = 2000
alter vosa dc = 0
alter vosb dc = 0
alter vosf1 dc = 0
alter vosf2 dc = 0
alter ratth = 1m
alter rattb = 10k
alter rl1 = 845
alter cwire = 100p
alter vk1i dc = 1
alter vk1t dc = 1.000000
alter vk5i dc = 1
alter vk5t dc = 1.000300
alter vt1ri dc = 1
alter vt1rt dc = 1000.000000
alter vt1si dc = 0
alter vt1st dc = 1000.000000
alter vt2ri dc = 1
alter vt2rt dc = 1000.000000
alter vt2si dc = 0
alter vt2st dc = 1000.000000
tran 1e-05 3.5 0 1e-05
wrdata gc10x0_lz$d v(mainjack) v(fixjack1) v(fixjack2)
wrdata gc10x0_lz_stati$d v(xls.xs) v(xlp.xs) v(dep) v(ina) v(vplus) v(vminus) v(main_a)
destroy all
echo "gc10x0_lz,gc10x0_lz.dat,caldo,1000,0,10a0,100k,1.0,1000,3.5,1e-05,evento,g0mai_lz,-,0.0,1,A_ins" >> tb_v2_casopeggiore_manifest.csv
alter vamp dc = 0
alter vfrq dc = 1000
alter rldm = 100k
alter rld1 = 100k
alter rld2 = 100k
alter vti dc = 1.0
alter vtr dc = 10.0
alter vtijk dc = 7.5
alter vtrjk dc = 10.0
alter vosa dc = 0
alter vosb dc = 0
alter vosf1 dc = 0
alter vosf2 dc = 0
alter ratth = 1m
alter rattb = 10k
alter rl1 = 845
alter cwire = 100p
alter vk1i dc = 0
alter vk1t dc = 8.000300
alter vk5i dc = 0
alter vk5t dc = 8.000000
alter vt1ri dc = 1
alter vt1rt dc = 1000.000000
alter vt1si dc = 0
alter vt1st dc = 1000.000000
alter vt2ri dc = 1
alter vt2rt dc = 1000.000000
alter vt2si dc = 0
alter vt2st dc = 1000.000000
tran 7e-06 19.0 0 7e-06
wrdata gm0x10p_lz$d v(mainjack) v(fixjack1) v(fixjack2)
destroy all
echo "pav_gm0x10_0,gm0x10p_lz.dat,pavimento,1000,0,0a10,100k,1.0,1000,19.0,7e-06,pav_num,gm0x10_lz_i,-,0.0,0," >> tb_v2_casopeggiore_manifest.csv
echo "pav_gm0x10_1,gm0x10p_lz.dat,pavimento,1000,0,0a10,100k,8.0,1000,19.0,7e-06,pav_num,gm0x10_lz_i,-,0.0,0," >> tb_v2_casopeggiore_manifest.csv
echo "pav_gm0x10_2,gm0x10p_lz.dat,pavimento,1000,0,0a10,100k,10.0,1000,19.0,7e-06,pav_num,gm0x10_lz_i,-,0.0,0," >> tb_v2_casopeggiore_manifest.csv
* ---- 1: 0 -> 10 dB sotto mute, 20k ----
alter vamp dc = 3.818
alter vfrq dc = 20000
alter rldm = 100k
alter rld1 = 100k
alter rld2 = 100k
alter vti dc = 1.0
alter vtr dc = 10.0
alter vtijk dc = 7.5
alter vtrjk dc = 10.0
alter vosa dc = 0
alter vosb dc = 0
alter vosf1 dc = 0
alter vosf2 dc = 0
alter ratth = 1m
alter rattb = 10k
alter rl1 = 845
alter cwire = 100p
alter vk1i dc = 0
alter vk1t dc = 8.000300
alter vk5i dc = 0
alter vk5t dc = 8.000000
alter vt1ri dc = 1
alter vt1rt dc = 1000.000000
alter vt1si dc = 0
alter vt1st dc = 1000.000000
alter vt2ri dc = 1
alter vt2rt dc = 1000.000000
alter vt2si dc = 0
alter vt2st dc = 1000.000000
tran 5e-07 19.0 0 5e-07
wrdata gm0x10_20k$d v(mainjack) v(fixjack1) v(fixjack2)
wrdata gm0x10_20k_stati$d v(xls.xs) v(xlp.xs) v(dep) v(ina) v(vplus) v(vminus) v(main_a)
destroy all
echo "gm0x10_20k_c,gm0x10_20k.dat,ldr_v4_td6_BB,20000,3.818,0a10,100k,8.0,10.0,19.0,5e-07,evento,-,g10mai_20k,0.0,1,S_rel;B2" >> tb_v2_casopeggiore_manifest.csv
* ---- 4: mute inv25, 1k ----
alter vamp dc = 3.818
alter vfrq dc = 1000
alter rldm = 100k
alter rld1 = 100k
alter rld2 = 100k
alter vti dc = 1.0
alter vtr dc = 2.5
alter vtijk dc = 1000
alter vtrjk dc = 2000
alter vosa dc = 0
alter vosb dc = 0
alter vosf1 dc = 0
alter vosf2 dc = 0
alter ratth = 1m
alter rattb = 10k
alter rl1 = 845
alter cwire = 100p
alter vk1i dc = 1
alter vk1t dc = 1000.000000
alter vk5i dc = 1
alter vk5t dc = 1000.000000
alter vt1ri dc = 1
alter vt1rt dc = 1000.000000
alter vt1si dc = 0
alter vt1st dc = 1000.000000
alter vt2ri dc = 1
alter vt2rt dc = 1000.000000
alter vt2si dc = 0
alter vt2st dc = 1000.000000
tran 1e-05 7.0 0 1e-05
wrdata minv25_1k$d v(mainjack) v(fixjack1) v(fixjack2)
wrdata minv25_1k_stati$d v(xls.xs) v(xlp.xs) v(dep) v(ina) v(vplus) v(vminus) v(main_a)
destroy all
echo "minv25_1k,minv25_1k.dat,ldr_v4_td6_BB_inv25,1000,3.818,10,100k,1.0,2.5,7.0,1e-05,evento,g10sempre_1k,g10mai_1k,1.5,4,S_ins;S_rel;B2" >> tb_v2_casopeggiore_manifest.csv
* ---- 4: mute inv50, 1k ----
alter vamp dc = 3.818
alter vfrq dc = 1000
alter rldm = 100k
alter rld1 = 100k
alter rld2 = 100k
alter vti dc = 1.0
alter vtr dc = 4.0
alter vtijk dc = 1000
alter vtrjk dc = 2000
alter vosa dc = 0
alter vosb dc = 0
alter vosf1 dc = 0
alter vosf2 dc = 0
alter ratth = 1m
alter rattb = 10k
alter rl1 = 845
alter cwire = 100p
alter vk1i dc = 1
alter vk1t dc = 1000.000000
alter vk5i dc = 1
alter vk5t dc = 1000.000000
alter vt1ri dc = 1
alter vt1rt dc = 1000.000000
alter vt1si dc = 0
alter vt1st dc = 1000.000000
alter vt2ri dc = 1
alter vt2rt dc = 1000.000000
alter vt2si dc = 0
alter vt2st dc = 1000.000000
tran 1e-05 10.0 0 1e-05
wrdata minv50_1k$d v(mainjack) v(fixjack1) v(fixjack2)
wrdata minv50_1k_stati$d v(xls.xs) v(xlp.xs) v(dep) v(ina) v(vplus) v(vminus) v(main_a)
destroy all
echo "minv50_1k,minv50_1k.dat,ldr_v4_td6_BB_inv50,1000,3.818,10,100k,1.0,4.0,10.0,1e-05,evento,g10sempre_1k,g10mai_1k,3.0,4,S_ins;S_rel;B2" >> tb_v2_casopeggiore_manifest.csv
* ---- 4: mute inv75, 1k ----
alter vamp dc = 3.818
alter vfrq dc = 1000
alter rldm = 100k
alter rld1 = 100k
alter rld2 = 100k
alter vti dc = 1.0
alter vtr dc = 5.5
alter vtijk dc = 1000
alter vtrjk dc = 2000
alter vosa dc = 0
alter vosb dc = 0
alter vosf1 dc = 0
alter vosf2 dc = 0
alter ratth = 1m
alter rattb = 10k
alter rl1 = 845
alter cwire = 100p
alter vk1i dc = 1
alter vk1t dc = 1000.000000
alter vk5i dc = 1
alter vk5t dc = 1000.000000
alter vt1ri dc = 1
alter vt1rt dc = 1000.000000
alter vt1si dc = 0
alter vt1st dc = 1000.000000
alter vt2ri dc = 1
alter vt2rt dc = 1000.000000
alter vt2si dc = 0
alter vt2st dc = 1000.000000
tran 1e-05 13.0 0 1e-05
wrdata minv75_1k$d v(mainjack) v(fixjack1) v(fixjack2)
wrdata minv75_1k_stati$d v(xls.xs) v(xlp.xs) v(dep) v(ina) v(vplus) v(vminus) v(main_a)
destroy all
echo "minv75_1k,minv75_1k.dat,ldr_v4_td6_BB_inv75,1000,3.818,10,100k,1.0,5.5,13.0,1e-05,evento,g10sempre_1k,g10mai_1k,4.5,4,S_ins;S_rel;B2" >> tb_v2_casopeggiore_manifest.csv
* ---- 4: mute h01, 1k ----
alter vamp dc = 3.818
alter vfrq dc = 1000
alter rldm = 100k
alter rld1 = 100k
alter rld2 = 100k
alter vti dc = 1.0
alter vtr dc = 7.6
alter vtijk dc = 7.5
alter vtrjk dc = 7.6
alter vosa dc = 0
alter vosb dc = 0
alter vosf1 dc = 0
alter vosf2 dc = 0
alter ratth = 1m
alter rattb = 10k
alter rl1 = 845
alter cwire = 100p
alter vk1i dc = 1
alter vk1t dc = 1000.000000
alter vk5i dc = 1
alter vk5t dc = 1000.000000
alter vt1ri dc = 1
alter vt1rt dc = 1000.000000
alter vt1si dc = 0
alter vt1st dc = 1000.000000
alter vt2ri dc = 1
alter vt2rt dc = 1000.000000
alter vt2si dc = 0
alter vt2st dc = 1000.000000
tran 1e-05 16.6 0 1e-05
wrdata mh01_1k$d v(mainjack) v(fixjack1) v(fixjack2)
wrdata mh01_1k_stati$d v(xls.xs) v(xlp.xs) v(dep) v(ina) v(vplus) v(vminus) v(main_a)
destroy all
echo "mh01_1k,mh01_1k.dat,ldr_v4_td6_BB_h01,1000,3.818,10,100k,1.0,7.6,16.6,1e-05,evento,g10sempre_1k,g10mai_1k,6.5,4,S_ins;S_rel;B2" >> tb_v2_casopeggiore_manifest.csv
* ---- 4: mute ev, 1k ----
alter vamp dc = 3.818
alter vfrq dc = 1000
alter rldm = 100k
alter rld1 = 100k
alter rld2 = 100k
alter vti dc = 1.0
alter vtr dc = 8.5
alter vtijk dc = 7.5
alter vtrjk dc = 8.5
alter vosa dc = 0
alter vosb dc = 0
alter vosf1 dc = 0
alter vosf2 dc = 0
alter ratth = 1m
alter rattb = 10k
alter rl1 = 845
alter cwire = 100p
alter vk1i dc = 1
alter vk1t dc = 1000.000000
alter vk5i dc = 1
alter vk5t dc = 1000.000000
alter vt1ri dc = 1
alter vt1rt dc = 1000.000000
alter vt1si dc = 0
alter vt1st dc = 1000.000000
alter vt2ri dc = 1
alter vt2rt dc = 1000.000000
alter vt2si dc = 0
alter vt2st dc = 1000.000000
tran 1e-05 17.5 0 1e-05
wrdata mev_1k$d v(mainjack) v(fixjack1) v(fixjack2)
wrdata mev_1k_stati$d v(xls.xs) v(xlp.xs) v(dep) v(ina) v(vplus) v(vminus) v(main_a)
destroy all
echo "mev_1k,mev_1k.dat,ldr_v4_td6_BB_ev,1000,3.818,10,100k,1.0,8.5,17.5,1e-05,evento,g10sempre_1k,g10mai_1k,6.5,4,S_ins;S_rel;B2" >> tb_v2_casopeggiore_manifest.csv
* ---- 4: mute h2, 1k ----
alter vamp dc = 3.818
alter vfrq dc = 1000
alter rldm = 100k
alter rld1 = 100k
alter rld2 = 100k
alter vti dc = 1.0
alter vtr dc = 9.5
alter vtijk dc = 7.5
alter vtrjk dc = 9.5
alter vosa dc = 0
alter vosb dc = 0
alter vosf1 dc = 0
alter vosf2 dc = 0
alter ratth = 1m
alter rattb = 10k
alter rl1 = 845
alter cwire = 100p
alter vk1i dc = 1
alter vk1t dc = 1000.000000
alter vk5i dc = 1
alter vk5t dc = 1000.000000
alter vt1ri dc = 1
alter vt1rt dc = 1000.000000
alter vt1si dc = 0
alter vt1st dc = 1000.000000
alter vt2ri dc = 1
alter vt2rt dc = 1000.000000
alter vt2si dc = 0
alter vt2st dc = 1000.000000
tran 1e-05 18.5 0 1e-05
wrdata mh2_1k$d v(mainjack) v(fixjack1) v(fixjack2)
wrdata mh2_1k_stati$d v(xls.xs) v(xlp.xs) v(dep) v(ina) v(vplus) v(vminus) v(main_a)
destroy all
echo "mh2_1k,mh2_1k.dat,ldr_v4_td6_BB_h2,1000,3.818,10,100k,1.0,9.5,18.5,1e-05,evento,g10sempre_1k,g10mai_1k,6.5,4,S_ins;S_rel;B2" >> tb_v2_casopeggiore_manifest.csv
* ---- 4: mute h20, 1k ----
alter vamp dc = 3.818
alter vfrq dc = 1000
alter rldm = 100k
alter rld1 = 100k
alter rld2 = 100k
alter vti dc = 1.0
alter vtr dc = 27.5
alter vtijk dc = 7.5
alter vtrjk dc = 27.5
alter vosa dc = 0
alter vosb dc = 0
alter vosf1 dc = 0
alter vosf2 dc = 0
alter ratth = 1m
alter rattb = 10k
alter rl1 = 845
alter cwire = 100p
alter vk1i dc = 1
alter vk1t dc = 1000.000000
alter vk5i dc = 1
alter vk5t dc = 1000.000000
alter vt1ri dc = 1
alter vt1rt dc = 1000.000000
alter vt1si dc = 0
alter vt1st dc = 1000.000000
alter vt2ri dc = 1
alter vt2rt dc = 1000.000000
alter vt2si dc = 0
alter vt2st dc = 1000.000000
tran 1e-05 36.5 0 1e-05
wrdata mh20_1k$d v(mainjack) v(fixjack1) v(fixjack2)
wrdata mh20_1k_stati$d v(xls.xs) v(xlp.xs) v(dep) v(ina) v(vplus) v(vminus) v(main_a)
destroy all
echo "mh20_1k,mh20_1k.dat,ldr_v4_td6_BB_h20,1000,3.818,10,100k,1.0,27.5,36.5,1e-05,evento,g10sempre_1k,g10mai_1k,6.5,4,S_ins;S_rel;B2" >> tb_v2_casopeggiore_manifest.csv
alter vamp dc = 3.818
alter vfrq dc = 1000
alter rldm = 100k
alter rld1 = 100k
alter rld2 = 100k
alter vti dc = 1.0
alter vtr dc = 8.5
alter vtijk dc = 1000
alter vtrjk dc = 2000
alter vosa dc = 0
alter vosb dc = 0
alter vosf1 dc = 0
alter vosf2 dc = 0
alter ratth = 1m
alter rattb = 10k
alter rl1 = 845
alter cwire = 100p
alter vk1i dc = 1
alter vk1t dc = 1000.000000
alter vk5i dc = 1
alter vk5t dc = 1000.000000
alter vt1ri dc = 1
alter vt1rt dc = 1000.000000
alter vt1si dc = 0
alter vt1st dc = 1000.000000
alter vt2ri dc = 1
alter vt2rt dc = 1000.000000
alter vt2si dc = 0
alter vt2st dc = 1000.000000
tran 1e-05 17.5 0 1e-05
wrdata mnorele_1k$d v(mainjack) v(fixjack1) v(fixjack2)
wrdata mnorele_1k_stati$d v(xls.xs) v(xlp.xs) v(dep) v(ina) v(vplus) v(vminus) v(main_a)
destroy all
echo "mnorele_1k,mnorele_1k.dat,rif,1000,3.818,10,100k,1.0,8.5,17.5,1e-05,rif_seq,-,-,0.0,0," >> tb_v2_casopeggiore_manifest.csv
echo "rele_1k,mev_1k.dat,rele_contro_norele,1000,3.818,10,100k,7.5,8.5,17.5,1e-05,evento,mnorele_1k,mnorele_1k,0.0,4,S_ins;S_rel" >> tb_v2_casopeggiore_manifest.csv
* ---- 4: mute inv25, 20 ----
alter vamp dc = 3.818
alter vfrq dc = 20
alter rldm = 100k
alter rld1 = 100k
alter rld2 = 100k
alter vti dc = 1.0
alter vtr dc = 2.5
alter vtijk dc = 1000
alter vtrjk dc = 2000
alter vosa dc = 0
alter vosb dc = 0
alter vosf1 dc = 0
alter vosf2 dc = 0
alter ratth = 1m
alter rattb = 10k
alter rl1 = 845
alter cwire = 100p
alter vk1i dc = 1
alter vk1t dc = 1000.000000
alter vk5i dc = 1
alter vk5t dc = 1000.000000
alter vt1ri dc = 1
alter vt1rt dc = 1000.000000
alter vt1si dc = 0
alter vt1st dc = 1000.000000
alter vt2ri dc = 1
alter vt2rt dc = 1000.000000
alter vt2si dc = 0
alter vt2st dc = 1000.000000
tran 1e-05 7.0 0 1e-05
wrdata minv25_20$d v(mainjack) v(fixjack1) v(fixjack2)
wrdata minv25_20_stati$d v(xls.xs) v(xlp.xs) v(dep) v(ina) v(vplus) v(vminus) v(main_a)
destroy all
echo "minv25_20,minv25_20.dat,ldr_v4_td6_BB_inv25,20,3.818,10,100k,1.0,2.5,7.0,1e-05,evento,g10sempre_20,g10mai_20,1.5,4,S_ins;S_rel;B2" >> tb_v2_casopeggiore_manifest.csv
* ---- 4: mute inv50, 20 ----
alter vamp dc = 3.818
alter vfrq dc = 20
alter rldm = 100k
alter rld1 = 100k
alter rld2 = 100k
alter vti dc = 1.0
alter vtr dc = 4.0
alter vtijk dc = 1000
alter vtrjk dc = 2000
alter vosa dc = 0
alter vosb dc = 0
alter vosf1 dc = 0
alter vosf2 dc = 0
alter ratth = 1m
alter rattb = 10k
alter rl1 = 845
alter cwire = 100p
alter vk1i dc = 1
alter vk1t dc = 1000.000000
alter vk5i dc = 1
alter vk5t dc = 1000.000000
alter vt1ri dc = 1
alter vt1rt dc = 1000.000000
alter vt1si dc = 0
alter vt1st dc = 1000.000000
alter vt2ri dc = 1
alter vt2rt dc = 1000.000000
alter vt2si dc = 0
alter vt2st dc = 1000.000000
tran 1e-05 10.0 0 1e-05
wrdata minv50_20$d v(mainjack) v(fixjack1) v(fixjack2)
wrdata minv50_20_stati$d v(xls.xs) v(xlp.xs) v(dep) v(ina) v(vplus) v(vminus) v(main_a)
destroy all
echo "minv50_20,minv50_20.dat,ldr_v4_td6_BB_inv50,20,3.818,10,100k,1.0,4.0,10.0,1e-05,evento,g10sempre_20,g10mai_20,3.0,4,S_ins;S_rel;B2" >> tb_v2_casopeggiore_manifest.csv
* ---- 4: mute inv75, 20 ----
alter vamp dc = 3.818
alter vfrq dc = 20
alter rldm = 100k
alter rld1 = 100k
alter rld2 = 100k
alter vti dc = 1.0
alter vtr dc = 5.5
alter vtijk dc = 1000
alter vtrjk dc = 2000
alter vosa dc = 0
alter vosb dc = 0
alter vosf1 dc = 0
alter vosf2 dc = 0
alter ratth = 1m
alter rattb = 10k
alter rl1 = 845
alter cwire = 100p
alter vk1i dc = 1
alter vk1t dc = 1000.000000
alter vk5i dc = 1
alter vk5t dc = 1000.000000
alter vt1ri dc = 1
alter vt1rt dc = 1000.000000
alter vt1si dc = 0
alter vt1st dc = 1000.000000
alter vt2ri dc = 1
alter vt2rt dc = 1000.000000
alter vt2si dc = 0
alter vt2st dc = 1000.000000
tran 1e-05 13.0 0 1e-05
wrdata minv75_20$d v(mainjack) v(fixjack1) v(fixjack2)
wrdata minv75_20_stati$d v(xls.xs) v(xlp.xs) v(dep) v(ina) v(vplus) v(vminus) v(main_a)
destroy all
echo "minv75_20,minv75_20.dat,ldr_v4_td6_BB_inv75,20,3.818,10,100k,1.0,5.5,13.0,1e-05,evento,g10sempre_20,g10mai_20,4.5,4,S_ins;S_rel;B2" >> tb_v2_casopeggiore_manifest.csv
* ---- 4: mute h01, 20 ----
alter vamp dc = 3.818
alter vfrq dc = 20
alter rldm = 100k
alter rld1 = 100k
alter rld2 = 100k
alter vti dc = 1.0
alter vtr dc = 7.6
alter vtijk dc = 7.5
alter vtrjk dc = 7.6
alter vosa dc = 0
alter vosb dc = 0
alter vosf1 dc = 0
alter vosf2 dc = 0
alter ratth = 1m
alter rattb = 10k
alter rl1 = 845
alter cwire = 100p
alter vk1i dc = 1
alter vk1t dc = 1000.000000
alter vk5i dc = 1
alter vk5t dc = 1000.000000
alter vt1ri dc = 1
alter vt1rt dc = 1000.000000
alter vt1si dc = 0
alter vt1st dc = 1000.000000
alter vt2ri dc = 1
alter vt2rt dc = 1000.000000
alter vt2si dc = 0
alter vt2st dc = 1000.000000
tran 1e-05 16.6 0 1e-05
wrdata mh01_20$d v(mainjack) v(fixjack1) v(fixjack2)
wrdata mh01_20_stati$d v(xls.xs) v(xlp.xs) v(dep) v(ina) v(vplus) v(vminus) v(main_a)
destroy all
echo "mh01_20,mh01_20.dat,ldr_v4_td6_BB_h01,20,3.818,10,100k,1.0,7.6,16.6,1e-05,evento,g10sempre_20,g10mai_20,6.5,4,S_ins;S_rel;B2" >> tb_v2_casopeggiore_manifest.csv
* ---- 4: mute ev, 20 ----
alter vamp dc = 3.818
alter vfrq dc = 20
alter rldm = 100k
alter rld1 = 100k
alter rld2 = 100k
alter vti dc = 1.0
alter vtr dc = 8.5
alter vtijk dc = 7.5
alter vtrjk dc = 8.5
alter vosa dc = 0
alter vosb dc = 0
alter vosf1 dc = 0
alter vosf2 dc = 0
alter ratth = 1m
alter rattb = 10k
alter rl1 = 845
alter cwire = 100p
alter vk1i dc = 1
alter vk1t dc = 1000.000000
alter vk5i dc = 1
alter vk5t dc = 1000.000000
alter vt1ri dc = 1
alter vt1rt dc = 1000.000000
alter vt1si dc = 0
alter vt1st dc = 1000.000000
alter vt2ri dc = 1
alter vt2rt dc = 1000.000000
alter vt2si dc = 0
alter vt2st dc = 1000.000000
tran 1e-05 17.5 0 1e-05
wrdata mev_20$d v(mainjack) v(fixjack1) v(fixjack2)
wrdata mev_20_stati$d v(xls.xs) v(xlp.xs) v(dep) v(ina) v(vplus) v(vminus) v(main_a)
destroy all
echo "mev_20,mev_20.dat,ldr_v4_td6_BB_ev,20,3.818,10,100k,1.0,8.5,17.5,1e-05,evento,g10sempre_20,g10mai_20,6.5,4,S_ins;S_rel;B2" >> tb_v2_casopeggiore_manifest.csv
* ---- 4: mute h2, 20 ----
alter vamp dc = 3.818
alter vfrq dc = 20
alter rldm = 100k
alter rld1 = 100k
alter rld2 = 100k
alter vti dc = 1.0
alter vtr dc = 9.5
alter vtijk dc = 7.5
alter vtrjk dc = 9.5
alter vosa dc = 0
alter vosb dc = 0
alter vosf1 dc = 0
alter vosf2 dc = 0
alter ratth = 1m
alter rattb = 10k
alter rl1 = 845
alter cwire = 100p
alter vk1i dc = 1
alter vk1t dc = 1000.000000
alter vk5i dc = 1
alter vk5t dc = 1000.000000
alter vt1ri dc = 1
alter vt1rt dc = 1000.000000
alter vt1si dc = 0
alter vt1st dc = 1000.000000
alter vt2ri dc = 1
alter vt2rt dc = 1000.000000
alter vt2si dc = 0
alter vt2st dc = 1000.000000
tran 1e-05 18.5 0 1e-05
wrdata mh2_20$d v(mainjack) v(fixjack1) v(fixjack2)
wrdata mh2_20_stati$d v(xls.xs) v(xlp.xs) v(dep) v(ina) v(vplus) v(vminus) v(main_a)
destroy all
echo "mh2_20,mh2_20.dat,ldr_v4_td6_BB_h2,20,3.818,10,100k,1.0,9.5,18.5,1e-05,evento,g10sempre_20,g10mai_20,6.5,4,S_ins;S_rel;B2" >> tb_v2_casopeggiore_manifest.csv
* ---- 4: mute h20, 20 ----
alter vamp dc = 3.818
alter vfrq dc = 20
alter rldm = 100k
alter rld1 = 100k
alter rld2 = 100k
alter vti dc = 1.0
alter vtr dc = 27.5
alter vtijk dc = 7.5
alter vtrjk dc = 27.5
alter vosa dc = 0
alter vosb dc = 0
alter vosf1 dc = 0
alter vosf2 dc = 0
alter ratth = 1m
alter rattb = 10k
alter rl1 = 845
alter cwire = 100p
alter vk1i dc = 1
alter vk1t dc = 1000.000000
alter vk5i dc = 1
alter vk5t dc = 1000.000000
alter vt1ri dc = 1
alter vt1rt dc = 1000.000000
alter vt1si dc = 0
alter vt1st dc = 1000.000000
alter vt2ri dc = 1
alter vt2rt dc = 1000.000000
alter vt2si dc = 0
alter vt2st dc = 1000.000000
tran 1e-05 36.5 0 1e-05
wrdata mh20_20$d v(mainjack) v(fixjack1) v(fixjack2)
wrdata mh20_20_stati$d v(xls.xs) v(xlp.xs) v(dep) v(ina) v(vplus) v(vminus) v(main_a)
destroy all
echo "mh20_20,mh20_20.dat,ldr_v4_td6_BB_h20,20,3.818,10,100k,1.0,27.5,36.5,1e-05,evento,g10sempre_20,g10mai_20,6.5,4,S_ins;S_rel;B2" >> tb_v2_casopeggiore_manifest.csv
alter vamp dc = 3.818
alter vfrq dc = 20
alter rldm = 100k
alter rld1 = 100k
alter rld2 = 100k
alter vti dc = 1.0
alter vtr dc = 8.5
alter vtijk dc = 1000
alter vtrjk dc = 2000
alter vosa dc = 0
alter vosb dc = 0
alter vosf1 dc = 0
alter vosf2 dc = 0
alter ratth = 1m
alter rattb = 10k
alter rl1 = 845
alter cwire = 100p
alter vk1i dc = 1
alter vk1t dc = 1000.000000
alter vk5i dc = 1
alter vk5t dc = 1000.000000
alter vt1ri dc = 1
alter vt1rt dc = 1000.000000
alter vt1si dc = 0
alter vt1st dc = 1000.000000
alter vt2ri dc = 1
alter vt2rt dc = 1000.000000
alter vt2si dc = 0
alter vt2st dc = 1000.000000
tran 1e-05 17.5 0 1e-05
wrdata mnorele_20$d v(mainjack) v(fixjack1) v(fixjack2)
wrdata mnorele_20_stati$d v(xls.xs) v(xlp.xs) v(dep) v(ina) v(vplus) v(vminus) v(main_a)
destroy all
echo "mnorele_20,mnorele_20.dat,rif,20,3.818,10,100k,1.0,8.5,17.5,1e-05,rif_seq,-,-,0.0,0," >> tb_v2_casopeggiore_manifest.csv
echo "rele_20,mev_20.dat,rele_contro_norele,20,3.818,10,100k,7.5,8.5,17.5,1e-05,evento,mnorele_20,mnorele_20,0.0,4,S_ins;S_rel" >> tb_v2_casopeggiore_manifest.csv
* ---- 4: mute inv25, lz ----
alter vamp dc = 0
alter vfrq dc = 1000
alter rldm = 100k
alter rld1 = 100k
alter rld2 = 100k
alter vti dc = 1.0
alter vtr dc = 2.5
alter vtijk dc = 1000
alter vtrjk dc = 2000
alter vosa dc = 0
alter vosb dc = 0
alter vosf1 dc = 0
alter vosf2 dc = 0
alter ratth = 1m
alter rattb = 10k
alter rl1 = 845
alter cwire = 100p
alter vk1i dc = 1
alter vk1t dc = 1000.000000
alter vk5i dc = 1
alter vk5t dc = 1000.000000
alter vt1ri dc = 1
alter vt1rt dc = 1000.000000
alter vt1si dc = 0
alter vt1st dc = 1000.000000
alter vt2ri dc = 1
alter vt2rt dc = 1000.000000
alter vt2si dc = 0
alter vt2st dc = 1000.000000
tran 1e-05 7.0 0 1e-05
wrdata minv25_lz$d v(mainjack) v(fixjack1) v(fixjack2)
wrdata minv25_lz_stati$d v(xls.xs) v(xlp.xs) v(dep) v(ina) v(vplus) v(vminus) v(main_a)
destroy all
echo "minv25_lz,minv25_lz.dat,ldr_v4_td6_BB_inv25,1000,0,10,100k,1.0,2.5,7.0,1e-05,evento,g10sempre_lz,g10mai_lz,1.5,4,A_ins;A_rel;B2" >> tb_v2_casopeggiore_manifest.csv
* ---- 4: mute inv50, lz ----
alter vamp dc = 0
alter vfrq dc = 1000
alter rldm = 100k
alter rld1 = 100k
alter rld2 = 100k
alter vti dc = 1.0
alter vtr dc = 4.0
alter vtijk dc = 1000
alter vtrjk dc = 2000
alter vosa dc = 0
alter vosb dc = 0
alter vosf1 dc = 0
alter vosf2 dc = 0
alter ratth = 1m
alter rattb = 10k
alter rl1 = 845
alter cwire = 100p
alter vk1i dc = 1
alter vk1t dc = 1000.000000
alter vk5i dc = 1
alter vk5t dc = 1000.000000
alter vt1ri dc = 1
alter vt1rt dc = 1000.000000
alter vt1si dc = 0
alter vt1st dc = 1000.000000
alter vt2ri dc = 1
alter vt2rt dc = 1000.000000
alter vt2si dc = 0
alter vt2st dc = 1000.000000
tran 1e-05 10.0 0 1e-05
wrdata minv50_lz$d v(mainjack) v(fixjack1) v(fixjack2)
wrdata minv50_lz_stati$d v(xls.xs) v(xlp.xs) v(dep) v(ina) v(vplus) v(vminus) v(main_a)
destroy all
echo "minv50_lz,minv50_lz.dat,ldr_v4_td6_BB_inv50,1000,0,10,100k,1.0,4.0,10.0,1e-05,evento,g10sempre_lz,g10mai_lz,3.0,4,A_ins;A_rel;B2" >> tb_v2_casopeggiore_manifest.csv
* ---- 4: mute inv75, lz ----
alter vamp dc = 0
alter vfrq dc = 1000
alter rldm = 100k
alter rld1 = 100k
alter rld2 = 100k
alter vti dc = 1.0
alter vtr dc = 5.5
alter vtijk dc = 1000
alter vtrjk dc = 2000
alter vosa dc = 0
alter vosb dc = 0
alter vosf1 dc = 0
alter vosf2 dc = 0
alter ratth = 1m
alter rattb = 10k
alter rl1 = 845
alter cwire = 100p
alter vk1i dc = 1
alter vk1t dc = 1000.000000
alter vk5i dc = 1
alter vk5t dc = 1000.000000
alter vt1ri dc = 1
alter vt1rt dc = 1000.000000
alter vt1si dc = 0
alter vt1st dc = 1000.000000
alter vt2ri dc = 1
alter vt2rt dc = 1000.000000
alter vt2si dc = 0
alter vt2st dc = 1000.000000
tran 1e-05 13.0 0 1e-05
wrdata minv75_lz$d v(mainjack) v(fixjack1) v(fixjack2)
wrdata minv75_lz_stati$d v(xls.xs) v(xlp.xs) v(dep) v(ina) v(vplus) v(vminus) v(main_a)
destroy all
echo "minv75_lz,minv75_lz.dat,ldr_v4_td6_BB_inv75,1000,0,10,100k,1.0,5.5,13.0,1e-05,evento,g10sempre_lz,g10mai_lz,4.5,4,A_ins;A_rel;B2" >> tb_v2_casopeggiore_manifest.csv
* ---- 4: mute h01, lz ----
alter vamp dc = 0
alter vfrq dc = 1000
alter rldm = 100k
alter rld1 = 100k
alter rld2 = 100k
alter vti dc = 1.0
alter vtr dc = 7.6
alter vtijk dc = 7.5
alter vtrjk dc = 7.6
alter vosa dc = 0
alter vosb dc = 0
alter vosf1 dc = 0
alter vosf2 dc = 0
alter ratth = 1m
alter rattb = 10k
alter rl1 = 845
alter cwire = 100p
alter vk1i dc = 1
alter vk1t dc = 1000.000000
alter vk5i dc = 1
alter vk5t dc = 1000.000000
alter vt1ri dc = 1
alter vt1rt dc = 1000.000000
alter vt1si dc = 0
alter vt1st dc = 1000.000000
alter vt2ri dc = 1
alter vt2rt dc = 1000.000000
alter vt2si dc = 0
alter vt2st dc = 1000.000000
tran 1e-05 16.6 0 1e-05
wrdata mh01_lz$d v(mainjack) v(fixjack1) v(fixjack2)
wrdata mh01_lz_stati$d v(xls.xs) v(xlp.xs) v(dep) v(ina) v(vplus) v(vminus) v(main_a)
destroy all
echo "mh01_lz,mh01_lz.dat,ldr_v4_td6_BB_h01,1000,0,10,100k,1.0,7.6,16.6,1e-05,evento,g10sempre_lz,g10mai_lz,6.5,4,A_ins;A_rel;B2" >> tb_v2_casopeggiore_manifest.csv
* ---- 4: mute ev, lz ----
alter vamp dc = 0
alter vfrq dc = 1000
alter rldm = 100k
alter rld1 = 100k
alter rld2 = 100k
alter vti dc = 1.0
alter vtr dc = 8.5
alter vtijk dc = 7.5
alter vtrjk dc = 8.5
alter vosa dc = 0
alter vosb dc = 0
alter vosf1 dc = 0
alter vosf2 dc = 0
alter ratth = 1m
alter rattb = 10k
alter rl1 = 845
alter cwire = 100p
alter vk1i dc = 1
alter vk1t dc = 1000.000000
alter vk5i dc = 1
alter vk5t dc = 1000.000000
alter vt1ri dc = 1
alter vt1rt dc = 1000.000000
alter vt1si dc = 0
alter vt1st dc = 1000.000000
alter vt2ri dc = 1
alter vt2rt dc = 1000.000000
alter vt2si dc = 0
alter vt2st dc = 1000.000000
tran 1e-05 17.5 0 1e-05
wrdata mev_lz$d v(mainjack) v(fixjack1) v(fixjack2)
wrdata mev_lz_stati$d v(xls.xs) v(xlp.xs) v(dep) v(ina) v(vplus) v(vminus) v(main_a)
destroy all
echo "mev_lz,mev_lz.dat,ldr_v4_td6_BB_ev,1000,0,10,100k,1.0,8.5,17.5,1e-05,evento,g10sempre_lz,g10mai_lz,6.5,4,A_ins;A_rel;B2" >> tb_v2_casopeggiore_manifest.csv
* ---- 4: mute h2, lz ----
alter vamp dc = 0
alter vfrq dc = 1000
alter rldm = 100k
alter rld1 = 100k
alter rld2 = 100k
alter vti dc = 1.0
alter vtr dc = 9.5
alter vtijk dc = 7.5
alter vtrjk dc = 9.5
alter vosa dc = 0
alter vosb dc = 0
alter vosf1 dc = 0
alter vosf2 dc = 0
alter ratth = 1m
alter rattb = 10k
alter rl1 = 845
alter cwire = 100p
alter vk1i dc = 1
alter vk1t dc = 1000.000000
alter vk5i dc = 1
alter vk5t dc = 1000.000000
alter vt1ri dc = 1
alter vt1rt dc = 1000.000000
alter vt1si dc = 0
alter vt1st dc = 1000.000000
alter vt2ri dc = 1
alter vt2rt dc = 1000.000000
alter vt2si dc = 0
alter vt2st dc = 1000.000000
tran 1e-05 18.5 0 1e-05
wrdata mh2_lz$d v(mainjack) v(fixjack1) v(fixjack2)
wrdata mh2_lz_stati$d v(xls.xs) v(xlp.xs) v(dep) v(ina) v(vplus) v(vminus) v(main_a)
destroy all
echo "mh2_lz,mh2_lz.dat,ldr_v4_td6_BB_h2,1000,0,10,100k,1.0,9.5,18.5,1e-05,evento,g10sempre_lz,g10mai_lz,6.5,4,A_ins;A_rel;B2" >> tb_v2_casopeggiore_manifest.csv
* ---- 4: mute h20, lz ----
alter vamp dc = 0
alter vfrq dc = 1000
alter rldm = 100k
alter rld1 = 100k
alter rld2 = 100k
alter vti dc = 1.0
alter vtr dc = 27.5
alter vtijk dc = 7.5
alter vtrjk dc = 27.5
alter vosa dc = 0
alter vosb dc = 0
alter vosf1 dc = 0
alter vosf2 dc = 0
alter ratth = 1m
alter rattb = 10k
alter rl1 = 845
alter cwire = 100p
alter vk1i dc = 1
alter vk1t dc = 1000.000000
alter vk5i dc = 1
alter vk5t dc = 1000.000000
alter vt1ri dc = 1
alter vt1rt dc = 1000.000000
alter vt1si dc = 0
alter vt1st dc = 1000.000000
alter vt2ri dc = 1
alter vt2rt dc = 1000.000000
alter vt2si dc = 0
alter vt2st dc = 1000.000000
tran 1e-05 36.5 0 1e-05
wrdata mh20_lz$d v(mainjack) v(fixjack1) v(fixjack2)
wrdata mh20_lz_stati$d v(xls.xs) v(xlp.xs) v(dep) v(ina) v(vplus) v(vminus) v(main_a)
destroy all
echo "mh20_lz,mh20_lz.dat,ldr_v4_td6_BB_h20,1000,0,10,100k,1.0,27.5,36.5,1e-05,evento,g10sempre_lz,g10mai_lz,6.5,4,A_ins;A_rel;B2" >> tb_v2_casopeggiore_manifest.csv
* ---- 4: mute h2, 20k ----
alter vamp dc = 3.818
alter vfrq dc = 20000
alter rldm = 100k
alter rld1 = 100k
alter rld2 = 100k
alter vti dc = 1.0
alter vtr dc = 9.5
alter vtijk dc = 7.5
alter vtrjk dc = 9.5
alter vosa dc = 0
alter vosb dc = 0
alter vosf1 dc = 0
alter vosf2 dc = 0
alter ratth = 1m
alter rattb = 10k
alter rl1 = 845
alter cwire = 100p
alter vk1i dc = 1
alter vk1t dc = 1000.000000
alter vk5i dc = 1
alter vk5t dc = 1000.000000
alter vt1ri dc = 1
alter vt1rt dc = 1000.000000
alter vt1si dc = 0
alter vt1st dc = 1000.000000
alter vt2ri dc = 1
alter vt2rt dc = 1000.000000
alter vt2si dc = 0
alter vt2st dc = 1000.000000
tran 5e-07 18.5 0 5e-07
wrdata mh2_20k$d v(mainjack) v(fixjack1) v(fixjack2)
wrdata mh2_20k_stati$d v(xls.xs) v(xlp.xs) v(dep) v(ina) v(vplus) v(vminus) v(main_a)
destroy all
echo "mh2_20k,mh2_20k.dat,ldr_v4_td6_BB_h2,20000,3.818,10,100k,1.0,9.5,18.5,5e-07,evento,-,g10mai_20k,6.5,4,S_ins;S_rel;B2" >> tb_v2_casopeggiore_manifest.csv
alter vamp dc = 0
alter vfrq dc = 1000
alter rldm = 100k
alter rld1 = 100k
alter rld2 = 100k
alter vti dc = 1.0
alter vtr dc = 8.5
alter vtijk dc = 7.5
alter vtrjk dc = 8.5
alter vosa dc = 0
alter vosb dc = 0
alter vosf1 dc = 0
alter vosf2 dc = 0
alter ratth = 1m
alter rattb = 10k
alter rl1 = 845
alter cwire = 100p
alter vk1i dc = 1
alter vk1t dc = 1000.000000
alter vk5i dc = 1
alter vk5t dc = 1000.000000
alter vt1ri dc = 1
alter vt1rt dc = 1000.000000
alter vt1si dc = 0
alter vt1st dc = 1000.000000
alter vt2ri dc = 1
alter vt2rt dc = 1000.000000
alter vt2si dc = 0
alter vt2st dc = 1000.000000
tran 7e-06 17.5 0 7e-06
wrdata mevp_lz$d v(mainjack) v(fixjack1) v(fixjack2)
destroy all
echo "pav_mev_0,mevp_lz.dat,pavimento,1000,0,10,100k,1.0,1000,17.5,7e-06,pav_num,mev_lz,-,0.0,0," >> tb_v2_casopeggiore_manifest.csv
echo "pav_mev_1,mevp_lz.dat,pavimento,1000,0,10,100k,7.5,1000,17.5,7e-06,pav_num,mev_lz,-,0.0,0," >> tb_v2_casopeggiore_manifest.csv
echo "pav_mev_2,mevp_lz.dat,pavimento,1000,0,10,100k,8.5,1000,17.5,7e-06,pav_num,mev_lz,-,0.0,0," >> tb_v2_casopeggiore_manifest.csv
* ---- 2: trim 0 -> -6 dB sotto mute, 1k ----
alter vamp dc = 3.818
alter vfrq dc = 1000
alter rldm = 100k
alter rld1 = 100k
alter rld2 = 100k
alter vti dc = 1.0
alter vtr dc = 10.0
alter vtijk dc = 7.5
alter vtrjk dc = 10.0
alter vosa dc = 0
alter vosb dc = 0
alter vosf1 dc = 0
alter vosf2 dc = 0
alter ratth = 1m
alter rattb = 10k
alter rl1 = 845
alter cwire = 100p
alter vk1i dc = 1
alter vk1t dc = 1000.000000
alter vk5i dc = 1
alter vk5t dc = 1000.000000
alter vt1ri dc = 1
alter vt1rt dc = 8.000000
alter vt1si dc = 0
alter vt1st dc = 8.001000
alter vt2ri dc = 1
alter vt2rt dc = 1000.000000
alter vt2si dc = 0
alter vt2st dc = 1000.000000
tran 1e-05 19.0 0 1e-05
wrdata tm0x6_1k$d v(mainjack) v(fixjack1) v(fixjack2)
wrdata tm0x6_1k_stati$d v(xls.xs) v(xlp.xs) v(dep) v(ina) v(vplus) v(vminus) v(main_a)
destroy all
echo "tm0x6_1k_i,tm0x6_1k.dat,ldr_v4_td6_BB,1000,3.818,t0a6,100k,1.0,8.0,19.0,1e-05,evento,g10sempre_1k,g10mai_1k,6.5,2,S_ins;B2" >> tb_v2_casopeggiore_manifest.csv
echo "tm0x6_1k_c,tm0x6_1k.dat,ldr_v4_td6_BB,1000,3.818,t0a6,100k,8.0,10.0,19.0,1e-05,evento,t6sempre_1k,t6mai_1k,0.0,2,S_rel;B2" >> tb_v2_casopeggiore_manifest.csv
* ---- 2: trim -6 -> 0 dB sotto mute, 1k ----
alter vamp dc = 3.818
alter vfrq dc = 1000
alter rldm = 100k
alter rld1 = 100k
alter rld2 = 100k
alter vti dc = 1.0
alter vtr dc = 10.0
alter vtijk dc = 7.5
alter vtrjk dc = 10.0
alter vosa dc = 0
alter vosb dc = 0
alter vosf1 dc = 0
alter vosf2 dc = 0
alter ratth = 1m
alter rattb = 10k
alter rl1 = 845
alter cwire = 100p
alter vk1i dc = 1
alter vk1t dc = 1000.000000
alter vk5i dc = 1
alter vk5t dc = 1000.000000
alter vt1ri dc = 0
alter vt1rt dc = 8.001000
alter vt1si dc = 1
alter vt1st dc = 8.000000
alter vt2ri dc = 1
alter vt2rt dc = 1000.000000
alter vt2si dc = 0
alter vt2st dc = 1000.000000
tran 1e-05 19.0 0 1e-05
wrdata tm6x0_1k$d v(mainjack) v(fixjack1) v(fixjack2)
wrdata tm6x0_1k_stati$d v(xls.xs) v(xlp.xs) v(dep) v(ina) v(vplus) v(vminus) v(main_a)
destroy all
echo "tm6x0_1k_i,tm6x0_1k.dat,ldr_v4_td6_BB,1000,3.818,t6a0,100k,1.0,8.0,19.0,1e-05,evento,t6sempre_1k,t6mai_1k,6.5,2,S_ins;B2" >> tb_v2_casopeggiore_manifest.csv
echo "tm6x0_1k_c,tm6x0_1k.dat,ldr_v4_td6_BB,1000,3.818,t6a0,100k,8.0,10.0,19.0,1e-05,evento,g10sempre_1k,g10mai_1k,0.0,2,S_rel;B2" >> tb_v2_casopeggiore_manifest.csv
* ---- 2: trim -6 -> -12 dB sotto mute, 1k ----
alter vamp dc = 3.818
alter vfrq dc = 1000
alter rldm = 100k
alter rld1 = 100k
alter rld2 = 100k
alter vti dc = 1.0
alter vtr dc = 10.0
alter vtijk dc = 7.5
alter vtrjk dc = 10.0
alter vosa dc = 0
alter vosb dc = 0
alter vosf1 dc = 0
alter vosf2 dc = 0
alter ratth = 1m
alter rattb = 10k
alter rl1 = 845
alter cwire = 100p
alter vk1i dc = 1
alter vk1t dc = 1000.000000
alter vk5i dc = 1
alter vk5t dc = 1000.000000
alter vt1ri dc = 0
alter vt1rt dc = 1000.000000
alter vt1si dc = 1
alter vt1st dc = 1000.000000
alter vt2ri dc = 1
alter vt2rt dc = 8.000000
alter vt2si dc = 0
alter vt2st dc = 8.001000
tran 1e-05 19.0 0 1e-05
wrdata tm6x12_1k$d v(mainjack) v(fixjack1) v(fixjack2)
wrdata tm6x12_1k_stati$d v(xls.xs) v(xlp.xs) v(dep) v(ina) v(vplus) v(vminus) v(main_a)
destroy all
echo "tm6x12_1k_i,tm6x12_1k.dat,ldr_v4_td6_BB,1000,3.818,t6a12,100k,1.0,8.0,19.0,1e-05,evento,t6sempre_1k,t6mai_1k,6.5,2,S_ins;B2" >> tb_v2_casopeggiore_manifest.csv
echo "tm6x12_1k_c,tm6x12_1k.dat,ldr_v4_td6_BB,1000,3.818,t6a12,100k,8.0,10.0,19.0,1e-05,evento,t12sempre_1k,t12mai_1k,0.0,2,S_rel;B2" >> tb_v2_casopeggiore_manifest.csv
* ---- 2: trim -12 -> -6 dB sotto mute, 1k ----
alter vamp dc = 3.818
alter vfrq dc = 1000
alter rldm = 100k
alter rld1 = 100k
alter rld2 = 100k
alter vti dc = 1.0
alter vtr dc = 10.0
alter vtijk dc = 7.5
alter vtrjk dc = 10.0
alter vosa dc = 0
alter vosb dc = 0
alter vosf1 dc = 0
alter vosf2 dc = 0
alter ratth = 1m
alter rattb = 10k
alter rl1 = 845
alter cwire = 100p
alter vk1i dc = 1
alter vk1t dc = 1000.000000
alter vk5i dc = 1
alter vk5t dc = 1000.000000
alter vt1ri dc = 0
alter vt1rt dc = 1000.000000
alter vt1si dc = 1
alter vt1st dc = 1000.000000
alter vt2ri dc = 0
alter vt2rt dc = 8.001000
alter vt2si dc = 1
alter vt2st dc = 8.000000
tran 1e-05 19.0 0 1e-05
wrdata tm12x6_1k$d v(mainjack) v(fixjack1) v(fixjack2)
wrdata tm12x6_1k_stati$d v(xls.xs) v(xlp.xs) v(dep) v(ina) v(vplus) v(vminus) v(main_a)
destroy all
echo "tm12x6_1k_i,tm12x6_1k.dat,ldr_v4_td6_BB,1000,3.818,t12a6,100k,1.0,8.0,19.0,1e-05,evento,t12sempre_1k,t12mai_1k,6.5,2,S_ins;B2" >> tb_v2_casopeggiore_manifest.csv
echo "tm12x6_1k_c,tm12x6_1k.dat,ldr_v4_td6_BB,1000,3.818,t12a6,100k,8.0,10.0,19.0,1e-05,evento,t6sempre_1k,t6mai_1k,0.0,2,S_rel;B2" >> tb_v2_casopeggiore_manifest.csv
* ---- 2: trim 0 -> -12 dB sotto mute, 1k ----
alter vamp dc = 3.818
alter vfrq dc = 1000
alter rldm = 100k
alter rld1 = 100k
alter rld2 = 100k
alter vti dc = 1.0
alter vtr dc = 10.0
alter vtijk dc = 7.5
alter vtrjk dc = 10.0
alter vosa dc = 0
alter vosb dc = 0
alter vosf1 dc = 0
alter vosf2 dc = 0
alter ratth = 1m
alter rattb = 10k
alter rl1 = 845
alter cwire = 100p
alter vk1i dc = 1
alter vk1t dc = 1000.000000
alter vk5i dc = 1
alter vk5t dc = 1000.000000
alter vt1ri dc = 1
alter vt1rt dc = 8.000000
alter vt1si dc = 0
alter vt1st dc = 8.001000
alter vt2ri dc = 1
alter vt2rt dc = 8.000000
alter vt2si dc = 0
alter vt2st dc = 8.001000
tran 1e-05 19.0 0 1e-05
wrdata tm0x12_1k$d v(mainjack) v(fixjack1) v(fixjack2)
wrdata tm0x12_1k_stati$d v(xls.xs) v(xlp.xs) v(dep) v(ina) v(vplus) v(vminus) v(main_a)
destroy all
echo "tm0x12_1k_i,tm0x12_1k.dat,ldr_v4_td6_BB,1000,3.818,t0a12,100k,1.0,8.0,19.0,1e-05,evento,g10sempre_1k,g10mai_1k,6.5,2,S_ins;B2" >> tb_v2_casopeggiore_manifest.csv
echo "tm0x12_1k_c,tm0x12_1k.dat,ldr_v4_td6_BB,1000,3.818,t0a12,100k,8.0,10.0,19.0,1e-05,evento,t12sempre_1k,t12mai_1k,0.0,2,S_rel;B2" >> tb_v2_casopeggiore_manifest.csv
* ---- 2: trim -12 -> 0 dB sotto mute, 1k ----
alter vamp dc = 3.818
alter vfrq dc = 1000
alter rldm = 100k
alter rld1 = 100k
alter rld2 = 100k
alter vti dc = 1.0
alter vtr dc = 10.0
alter vtijk dc = 7.5
alter vtrjk dc = 10.0
alter vosa dc = 0
alter vosb dc = 0
alter vosf1 dc = 0
alter vosf2 dc = 0
alter ratth = 1m
alter rattb = 10k
alter rl1 = 845
alter cwire = 100p
alter vk1i dc = 1
alter vk1t dc = 1000.000000
alter vk5i dc = 1
alter vk5t dc = 1000.000000
alter vt1ri dc = 0
alter vt1rt dc = 8.001000
alter vt1si dc = 1
alter vt1st dc = 8.000000
alter vt2ri dc = 0
alter vt2rt dc = 8.001000
alter vt2si dc = 1
alter vt2st dc = 8.000000
tran 1e-05 19.0 0 1e-05
wrdata tm12x0_1k$d v(mainjack) v(fixjack1) v(fixjack2)
wrdata tm12x0_1k_stati$d v(xls.xs) v(xlp.xs) v(dep) v(ina) v(vplus) v(vminus) v(main_a)
destroy all
echo "tm12x0_1k_i,tm12x0_1k.dat,ldr_v4_td6_BB,1000,3.818,t12a0,100k,1.0,8.0,19.0,1e-05,evento,t12sempre_1k,t12mai_1k,6.5,2,S_ins;B2" >> tb_v2_casopeggiore_manifest.csv
echo "tm12x0_1k_c,tm12x0_1k.dat,ldr_v4_td6_BB,1000,3.818,t12a0,100k,8.0,10.0,19.0,1e-05,evento,g10sempre_1k,g10mai_1k,0.0,2,S_rel;B2" >> tb_v2_casopeggiore_manifest.csv
* ---- 2: trim 0 -> -6 dB sotto mute, lz ----
alter vamp dc = 0
alter vfrq dc = 1000
alter rldm = 100k
alter rld1 = 100k
alter rld2 = 100k
alter vti dc = 1.0
alter vtr dc = 10.0
alter vtijk dc = 7.5
alter vtrjk dc = 10.0
alter vosa dc = 0
alter vosb dc = 0
alter vosf1 dc = 0
alter vosf2 dc = 0
alter ratth = 1m
alter rattb = 10k
alter rl1 = 845
alter cwire = 100p
alter vk1i dc = 1
alter vk1t dc = 1000.000000
alter vk5i dc = 1
alter vk5t dc = 1000.000000
alter vt1ri dc = 1
alter vt1rt dc = 8.000000
alter vt1si dc = 0
alter vt1st dc = 8.001000
alter vt2ri dc = 1
alter vt2rt dc = 1000.000000
alter vt2si dc = 0
alter vt2st dc = 1000.000000
tran 1e-05 19.0 0 1e-05
wrdata tm0x6_lz$d v(mainjack) v(fixjack1) v(fixjack2)
wrdata tm0x6_lz_stati$d v(xls.xs) v(xlp.xs) v(dep) v(ina) v(vplus) v(vminus) v(main_a)
destroy all
echo "tm0x6_lz_i,tm0x6_lz.dat,ldr_v4_td6_BB,1000,0,t0a6,100k,1.0,8.0,19.0,1e-05,evento,g10sempre_lz,g10mai_lz,6.5,2,A_ins;B2" >> tb_v2_casopeggiore_manifest.csv
echo "tm0x6_lz_c,tm0x6_lz.dat,ldr_v4_td6_BB,1000,0,t0a6,100k,8.0,10.0,19.0,1e-05,evento,t6sempre_lz,t6mai_lz,0.0,2,A_ins;A_rel;B2" >> tb_v2_casopeggiore_manifest.csv
* ---- 2: trim -6 -> 0 dB sotto mute, lz ----
alter vamp dc = 0
alter vfrq dc = 1000
alter rldm = 100k
alter rld1 = 100k
alter rld2 = 100k
alter vti dc = 1.0
alter vtr dc = 10.0
alter vtijk dc = 7.5
alter vtrjk dc = 10.0
alter vosa dc = 0
alter vosb dc = 0
alter vosf1 dc = 0
alter vosf2 dc = 0
alter ratth = 1m
alter rattb = 10k
alter rl1 = 845
alter cwire = 100p
alter vk1i dc = 1
alter vk1t dc = 1000.000000
alter vk5i dc = 1
alter vk5t dc = 1000.000000
alter vt1ri dc = 0
alter vt1rt dc = 8.001000
alter vt1si dc = 1
alter vt1st dc = 8.000000
alter vt2ri dc = 1
alter vt2rt dc = 1000.000000
alter vt2si dc = 0
alter vt2st dc = 1000.000000
tran 1e-05 19.0 0 1e-05
wrdata tm6x0_lz$d v(mainjack) v(fixjack1) v(fixjack2)
wrdata tm6x0_lz_stati$d v(xls.xs) v(xlp.xs) v(dep) v(ina) v(vplus) v(vminus) v(main_a)
destroy all
echo "tm6x0_lz_i,tm6x0_lz.dat,ldr_v4_td6_BB,1000,0,t6a0,100k,1.0,8.0,19.0,1e-05,evento,t6sempre_lz,t6mai_lz,6.5,2,A_ins;B2" >> tb_v2_casopeggiore_manifest.csv
echo "tm6x0_lz_c,tm6x0_lz.dat,ldr_v4_td6_BB,1000,0,t6a0,100k,8.0,10.0,19.0,1e-05,evento,g10sempre_lz,g10mai_lz,0.0,2,A_ins;A_rel;B2" >> tb_v2_casopeggiore_manifest.csv
* ---- 2: trim -6 -> -12 dB sotto mute, lz ----
alter vamp dc = 0
alter vfrq dc = 1000
alter rldm = 100k
alter rld1 = 100k
alter rld2 = 100k
alter vti dc = 1.0
alter vtr dc = 10.0
alter vtijk dc = 7.5
alter vtrjk dc = 10.0
alter vosa dc = 0
alter vosb dc = 0
alter vosf1 dc = 0
alter vosf2 dc = 0
alter ratth = 1m
alter rattb = 10k
alter rl1 = 845
alter cwire = 100p
alter vk1i dc = 1
alter vk1t dc = 1000.000000
alter vk5i dc = 1
alter vk5t dc = 1000.000000
alter vt1ri dc = 0
alter vt1rt dc = 1000.000000
alter vt1si dc = 1
alter vt1st dc = 1000.000000
alter vt2ri dc = 1
alter vt2rt dc = 8.000000
alter vt2si dc = 0
alter vt2st dc = 8.001000
tran 1e-05 19.0 0 1e-05
wrdata tm6x12_lz$d v(mainjack) v(fixjack1) v(fixjack2)
wrdata tm6x12_lz_stati$d v(xls.xs) v(xlp.xs) v(dep) v(ina) v(vplus) v(vminus) v(main_a)
destroy all
echo "tm6x12_lz_i,tm6x12_lz.dat,ldr_v4_td6_BB,1000,0,t6a12,100k,1.0,8.0,19.0,1e-05,evento,t6sempre_lz,t6mai_lz,6.5,2,A_ins;B2" >> tb_v2_casopeggiore_manifest.csv
echo "tm6x12_lz_c,tm6x12_lz.dat,ldr_v4_td6_BB,1000,0,t6a12,100k,8.0,10.0,19.0,1e-05,evento,t12sempre_lz,t12mai_lz,0.0,2,A_ins;A_rel;B2" >> tb_v2_casopeggiore_manifest.csv
* ---- 2: trim -12 -> -6 dB sotto mute, lz ----
alter vamp dc = 0
alter vfrq dc = 1000
alter rldm = 100k
alter rld1 = 100k
alter rld2 = 100k
alter vti dc = 1.0
alter vtr dc = 10.0
alter vtijk dc = 7.5
alter vtrjk dc = 10.0
alter vosa dc = 0
alter vosb dc = 0
alter vosf1 dc = 0
alter vosf2 dc = 0
alter ratth = 1m
alter rattb = 10k
alter rl1 = 845
alter cwire = 100p
alter vk1i dc = 1
alter vk1t dc = 1000.000000
alter vk5i dc = 1
alter vk5t dc = 1000.000000
alter vt1ri dc = 0
alter vt1rt dc = 1000.000000
alter vt1si dc = 1
alter vt1st dc = 1000.000000
alter vt2ri dc = 0
alter vt2rt dc = 8.001000
alter vt2si dc = 1
alter vt2st dc = 8.000000
tran 1e-05 19.0 0 1e-05
wrdata tm12x6_lz$d v(mainjack) v(fixjack1) v(fixjack2)
wrdata tm12x6_lz_stati$d v(xls.xs) v(xlp.xs) v(dep) v(ina) v(vplus) v(vminus) v(main_a)
destroy all
echo "tm12x6_lz_i,tm12x6_lz.dat,ldr_v4_td6_BB,1000,0,t12a6,100k,1.0,8.0,19.0,1e-05,evento,t12sempre_lz,t12mai_lz,6.5,2,A_ins;B2" >> tb_v2_casopeggiore_manifest.csv
echo "tm12x6_lz_c,tm12x6_lz.dat,ldr_v4_td6_BB,1000,0,t12a6,100k,8.0,10.0,19.0,1e-05,evento,t6sempre_lz,t6mai_lz,0.0,2,A_ins;A_rel;B2" >> tb_v2_casopeggiore_manifest.csv
* ---- 2: trim 0 -> -12 dB sotto mute, lz ----
alter vamp dc = 0
alter vfrq dc = 1000
alter rldm = 100k
alter rld1 = 100k
alter rld2 = 100k
alter vti dc = 1.0
alter vtr dc = 10.0
alter vtijk dc = 7.5
alter vtrjk dc = 10.0
alter vosa dc = 0
alter vosb dc = 0
alter vosf1 dc = 0
alter vosf2 dc = 0
alter ratth = 1m
alter rattb = 10k
alter rl1 = 845
alter cwire = 100p
alter vk1i dc = 1
alter vk1t dc = 1000.000000
alter vk5i dc = 1
alter vk5t dc = 1000.000000
alter vt1ri dc = 1
alter vt1rt dc = 8.000000
alter vt1si dc = 0
alter vt1st dc = 8.001000
alter vt2ri dc = 1
alter vt2rt dc = 8.000000
alter vt2si dc = 0
alter vt2st dc = 8.001000
tran 1e-05 19.0 0 1e-05
wrdata tm0x12_lz$d v(mainjack) v(fixjack1) v(fixjack2)
wrdata tm0x12_lz_stati$d v(xls.xs) v(xlp.xs) v(dep) v(ina) v(vplus) v(vminus) v(main_a)
destroy all
echo "tm0x12_lz_i,tm0x12_lz.dat,ldr_v4_td6_BB,1000,0,t0a12,100k,1.0,8.0,19.0,1e-05,evento,g10sempre_lz,g10mai_lz,6.5,2,A_ins;B2" >> tb_v2_casopeggiore_manifest.csv
echo "tm0x12_lz_c,tm0x12_lz.dat,ldr_v4_td6_BB,1000,0,t0a12,100k,8.0,10.0,19.0,1e-05,evento,t12sempre_lz,t12mai_lz,0.0,2,A_ins;A_rel;B2" >> tb_v2_casopeggiore_manifest.csv
* ---- 2: trim -12 -> 0 dB sotto mute, lz ----
alter vamp dc = 0
alter vfrq dc = 1000
alter rldm = 100k
alter rld1 = 100k
alter rld2 = 100k
alter vti dc = 1.0
alter vtr dc = 10.0
alter vtijk dc = 7.5
alter vtrjk dc = 10.0
alter vosa dc = 0
alter vosb dc = 0
alter vosf1 dc = 0
alter vosf2 dc = 0
alter ratth = 1m
alter rattb = 10k
alter rl1 = 845
alter cwire = 100p
alter vk1i dc = 1
alter vk1t dc = 1000.000000
alter vk5i dc = 1
alter vk5t dc = 1000.000000
alter vt1ri dc = 0
alter vt1rt dc = 8.001000
alter vt1si dc = 1
alter vt1st dc = 8.000000
alter vt2ri dc = 0
alter vt2rt dc = 8.001000
alter vt2si dc = 1
alter vt2st dc = 8.000000
tran 1e-05 19.0 0 1e-05
wrdata tm12x0_lz$d v(mainjack) v(fixjack1) v(fixjack2)
wrdata tm12x0_lz_stati$d v(xls.xs) v(xlp.xs) v(dep) v(ina) v(vplus) v(vminus) v(main_a)
destroy all
echo "tm12x0_lz_i,tm12x0_lz.dat,ldr_v4_td6_BB,1000,0,t12a0,100k,1.0,8.0,19.0,1e-05,evento,t12sempre_lz,t12mai_lz,6.5,2,A_ins;B2" >> tb_v2_casopeggiore_manifest.csv
echo "tm12x0_lz_c,tm12x0_lz.dat,ldr_v4_td6_BB,1000,0,t12a0,100k,8.0,10.0,19.0,1e-05,evento,g10sempre_lz,g10mai_lz,0.0,2,A_ins;A_rel;B2" >> tb_v2_casopeggiore_manifest.csv
.endc

.end
