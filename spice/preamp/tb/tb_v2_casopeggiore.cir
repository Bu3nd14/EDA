tb_v2_casopeggiore.cir - V2 al jack, il caso peggiore col mute reale: LDR VTL5C4 v4 a monte e rele' al jack, guadagno, trim, dispersione, accensione (L29c, NC-028)
* Prima riga = titolo (docs/limitations.md #10).
* GENERATO da docs/preamp/data/2026-09-23/L29c/deck/genera_tb_v2_casopeggiore.py: non si
* edita a mano. L'intestazione del generatore dice cosa c'e' dentro, le ipotesi di
* accensione e spegnimento, e come si corre. Matrice: sorgente. Curve: serie B, derivazione B.
* MATRICE sorgente (L29e, ADR-044): il mute al jack e' la geometria iii com'e' in
* circuits/preamp/preamp_audio.net - un deviatore per uscita, COM al lato del condensatore,
* NC a massa, NO al jack. Il generatore la LEGGE dalla netlist col controllo del 2e e rifiuta
* se non c'e'; i bleed lato condensatore (rbcm/rbc1/rbc2) sono i valori della netlist, il
* bleed del jack deve coincidere con RBLx del blocco. Dal banco restano: il contatto aperto
* 0,1 pF (datasheet, L29d2), il trasferimento 1 ms (ipotesi) e 0 pF di cavo (caso peggiore).
* Nomi e righe sono quelli di L29d2 (suffisso _iii), variante di progetto.
*
* IL MODELLO DELLE CELLE e' comportamentale dal datasheet, con estrapolazione dichiarata
* (models/optocoupler/vtl5c4_comportamentale.lib). Ogni dispositivo attivo e' il modello del
* costruttore in models/ (L39); nessuno porta la dispersione, che qui si inietta: VOS* e
* `altermod lsk489a vto` (gruppo B, ADR-031). UN MODELLO ALTERATO PORTA ANCORA IL NOME
* LSK489A (limitations #29): le corse alterate lo dicono nel nome (_gb*) e stampano showmod
* e la corrente della sonda JPRB.
*
* IL PROFILO v4, Td 6 s (ADR-039, ADR-040). Rele' al jack chiuso 0,5 s dopo d = 1.
* ANALISI: scripts/v2_metodo.py analizza sul manifesto; le colonne gruppo e conta dicono
* quali grandezze di ogni riga sono verdetto. Si corre DIVISO (dividi.py): le corse di
* accensione alterano le sorgenti dei rail, e in sequenza l'alterazione resterebbe.
* CONVENZIONE DI PERCORSO: `.include @REPO@/...` (tb_op.cir, L2-L3).

.include @REPO@/models/jfet/lsk489.lib
.include @REPO@/models/bjt_npn/mmbt5551.lib
.include @REPO@/models/bjt_pnp/mmbt5401.lib
.include @REPO@/models/bjt_npn/mje15032.lib
.include @REPO@/models/bjt_pnp/mje15033.lib
.include @REPO@/models/diodes/1n4148.lib
.include @REPO@/models/bjt_pnp/ls350.lib
.include @REPO@/spice/preamp/gain_block.subckt
.include @REPO@/models/optocoupler/vtl5c4_comportamentale.lib

* >>> CANALE - identico nei tre deck tb_v2_mute_*.cir (v2_metodo.py canale)
* TOLLERANZE (L29a, ripresa 2026-09-16): vedi il blocco esteso in
* tb_v2_mute_varianti.cir. vntol=1e-9 rendeva il deck non eseguibile (41 ore
* per una cella senza segnale); vntol=1e-6 la fa in 5,5 s e le cifre non
* cambiano - verificato, data/2026-09-16/L29a/tolleranze/.
.options reltol=1e-6 vntol=1e-6 abstol=1e-12
VPP VPLUS 0 DC 15
VMM VMINUS 0 DC -15

* ---- sorgente con inviluppo d'entrata ----
VAMP NAMP 0 DC 3.818
VFRQ NFRQ 0 DC 1000
VPHS NPHS 0 DC 0
VTEN NTEN 0 DC 0.3
BSRC SRC 0 V = V(NAMP) * sin(6.283185307179586*V(NFRQ)*time + V(NPHS))
+ * (0.5 - 0.5*cos(3.141592653589793*min(time/V(NTEN), 1)))
RSRC SRC SELA 1.5

* ---- stati dei contatti: t_ins, t_rel, durata graduale, netto(1)/graduale(0) ----
VTIJK NTIJK 0 DC 1000
VTRJK NTRJK 0 DC 2000
VTGJK NTGJK 0 DC 1
VMHJK NMHJK 0 DC 1
BSJKR SJKR 0 V = V(NMHJK)
+ * pwl(time - V(NTIJK), -1e4,0, 0,0, 1u,1, 150u,1, 151u,0, 300u,0, 301u,1, 450u,1, 451u,0, 520u,0, 521u,1, 1e4,1)
+ * pwl(time - V(NTRJK), -1e4,1, 0,1, 1u,0, 400u,0, 401u,1, 600u,1, 601u,0, 1e4,0)
+ + (1 - V(NMHJK)) * min(max((time - V(NTIJK))/V(NTGJK), 0), 1)
+ * (1 - min(max((time - V(NTRJK))/V(NTGJK), 0), 1))
RSJK SJKR SJK 1k
CSJK SJK 0 4.55n
VTIPRE NTIPRE 0 DC 1000
VTRPRE NTRPRE 0 DC 2000
VTGPRE NTGPRE 0 DC 1
VMHPRE NMHPRE 0 DC 1
BSPRER SPRER 0 V = V(NMHPRE)
+ * pwl(time - V(NTIPRE), -1e4,0, 0,0, 1u,1, 150u,1, 151u,0, 300u,0, 301u,1, 450u,1, 451u,0, 520u,0, 521u,1, 1e4,1)
+ * pwl(time - V(NTRPRE), -1e4,1, 0,1, 1u,0, 400u,0, 401u,1, 600u,1, 601u,0, 1e4,0)
+ + (1 - V(NMHPRE)) * min(max((time - V(NTIPRE))/V(NTGPRE), 0), 1)
+ * (1 - min(max((time - V(NTRPRE))/V(NTGPRE), 0), 1))
RSPRE SPRER SPRE 1k
CSPRE SPRE 0 4.55n
VTISER NTISER 0 DC 1000
VTRSER NTRSER 0 DC 2000
VTGSER NTGSER 0 DC 1
VMHSER NMHSER 0 DC 1
BSSERR SSERR 0 V = V(NMHSER)
+ * pwl(time - V(NTISER), -1e4,0, 0,0, 1u,1, 150u,1, 151u,0, 300u,0, 301u,1, 450u,1, 451u,0, 520u,0, 521u,1, 1e4,1)
+ * pwl(time - V(NTRSER), -1e4,1, 0,1, 1u,0, 400u,0, 401u,1, 600u,1, 601u,0, 1e4,0)
+ + (1 - V(NMHSER)) * min(max((time - V(NTISER))/V(NTGSER), 0), 1)
+ * (1 - min(max((time - V(NTRSER))/V(NTGSER), 0), 1))
RSSER SSERR SSER 1k
CSSER SSER 0 4.55n
VTISEL NTISEL 0 DC 1000
VTRSEL NTRSEL 0 DC 2000
VTGSEL NTGSEL 0 DC 1
VMHSEL NMHSEL 0 DC 1
BSSELR SSELR 0 V = V(NMHSEL)
+ * pwl(time - V(NTISEL), -1e4,0, 0,0, 1u,1, 150u,1, 151u,0, 300u,0, 301u,1, 450u,1, 451u,0, 520u,0, 521u,1, 1e4,1)
+ * pwl(time - V(NTRSEL), -1e4,1, 0,1, 1u,0, 400u,0, 401u,1, 600u,1, 601u,0, 1e4,0)
+ + (1 - V(NMHSEL)) * min(max((time - V(NTISEL))/V(NTGSEL), 0), 1)
+ * (1 - min(max((time - V(NTRSEL))/V(NTGSEL), 0), 1))
RSSEL SSELR SSEL 1k
CSSEL SSEL 0 4.55n

* ---- selettore d'ingresso: serie, s = 1 vuol dire APERTO ----
BSEL SELA INA I = V(SELA,INA) * pow(10, -12 + 13*(1 - V(SSEL)))

* ---------------- BLOCCO A: guadagno 1, R_g non montata ------------------
VOSA INA INAX DC 0
XA INAX OUTA FBA RGA RG10A VPLUS VMINUS GAINBLOCK
RRGA RGA 0 1G
CRGA RGA 0 15p
RRG10A RG10A 0 1G
CRG10A RG10A 0 15p

* Attenuatore da 10 k: RATTT a 1 mohm = manopola al massimo.
RATTT OUTA W 1m
RATTB W 0 10k

* ---------------- BUFFER DELLE FISSE (ADR-023): guadagno 1 ---------------
VOSF1 OUTA F1IN DC 0
XF1 F1IN OUTF1 FBF1 RGF1 RG10F1 VPLUS VMINUS GAINBLOCK
RRGF1 RGF1 0 1G
CRGF1 RGF1 0 15p
RRG10F1 RG10F1 0 1G
CRG10F1 RG10F1 0 15p
VOSF2 OUTA F2IN DC 0
XF2 F2IN OUTF2 FBF2 RGF2 RG10F2 VPLUS VMINUS GAINBLOCK
RRGF2 RGF2 0 1G
CRGF2 RGF2 0 15p
RRG10F2 RG10F2 0 1G
CRG10F2 RG10F2 0 15p

RSEP1 OUTF1 FIX1 47
BPRE1 FIX1 0 I = V(FIX1) * pow(10, -12 + 13*V(SPRE))
CFIX1 FIX1 FIXC1 4.7u
RBC1 FIXC1 0 1e12
RBY1 FIXC1 FIXJACK1 1m
BSER1 FIXC1 FIXJACK1 I = V(FIXC1,FIXJACK1) * pow(10, -12 + 13*(1 - V(SSER)))
BJK1 FIXJACK1 0 I = V(FIXJACK1) * pow(10, -12 + 13*V(SJK))
RBL1 FIXJACK1 0 470k
RLD1 FIXJACK1 0 100k

RSEP2 OUTF2 FIX2 47
BPRE2 FIX2 0 I = V(FIX2) * pow(10, -12 + 13*V(SPRE))
CFIX2 FIX2 FIXC2 4.7u
RBC2 FIXC2 0 1e12
RBY2 FIXC2 FIXJACK2 1m
BSER2 FIXC2 FIXJACK2 I = V(FIXC2,FIXJACK2) * pow(10, -12 + 13*(1 - V(SSER)))
BJK2 FIXJACK2 0 I = V(FIXJACK2) * pow(10, -12 + 13*V(SJK))
RBL2 FIXJACK2 0 470k
RLD2 FIXJACK2 0 100k

* ---------------- BLOCCO B: 0 / +3 / +10 dB, due rele' su R_g ------------
* Contatto aperto = 1 G + 15 pF, chiuso = alter ... = 0.1 (ADR-026):
*   0 dB   rrgb = 1G    rrg10b = 1G
*   +3 dB  rrgb = 0.1   rrg10b = 1G
*   +10 dB rrgb = 0.1   rrg10b = 0.1
VOSB W WB DC 0
XB WB OUTB FBB RGB RG10B VPLUS VMINUS GAINBLOCK
RRGB RGB 0 1G
CRGB RGB 0 15p
RRG10B RG10B 0 1G
CRG10B RG10B 0 15p
RISOM OUTB MAIN_A 47
BPREM MAIN_A 0 I = V(MAIN_A) * pow(10, -12 + 13*V(SPRE))
COUTM MAIN_A MAINC 4.7u
RBCM MAINC 0 1e12
RBYM MAINC MAINJACK 1m
BSERM MAINC MAINJACK I = V(MAINC,MAINJACK) * pow(10, -12 + 13*(1 - V(SSER)))
BJKM MAINJACK 0 I = V(MAINJACK) * pow(10, -12 + 13*V(SJK))
RBLM MAINJACK 0 220k
RLDM MAINJACK 0 100k
* <<< CANALE
* ---- L29b2: le due LDR e il loro comando, fuori dal blocco CANALE (ADR-038) ----
VTI NTI 0 DC 1000
VTR NTR 0 DC 2000
VTD NTD 0 DC 6
BDIN DIN 0 V = min(max((time - V(NTI))/V(NTD), 0), 1)
BDEP DEP 0 V = time < V(NTR) ? V(DIN) : max(min(max((V(NTR) - V(NTI))/V(NTD), 0), 1) - (time - V(NTR))/V(NTD), 0)
BILS 0 ALS I = V(NPWL) * pow(10, pwl(V(DEP), 0,-1.6990, 0.1,-3.6990, 0.45,-5.3468, 0.75,-6.7212, 0.8,-8.0000, 1,-8.0000))
BILP 0 ALP I = V(NPWL) * 1e-08 * pow(2e+06, min(max((V(DEP) - 0.5)/0.5, 0), 1))
* 10 M dall'anodo a massa: un LED col solo generatore non ha percorso in continua e l'op
* fallisce in silenzio (trappola di L29b). E' del banco, non della scheda.
RALS ALS 0 10MEG
RALP ALP 0 10MEG
RSRC2 SRC SRCX 1.5
XLS ALS 0 SRCX SELA VTL5C4_B
XLP ALP 0 INA 0 VTL5C4_B

* ---- L29c: i contatti del guadagno, in parallelo a RRGB / RRG10B del blocco ----
* interruttore nativo: 0,1 ohm chiuso (il massimo del G6K), 1 T aperto; soglia 0,5 V sulla
* pwl 0/1 dei rimbalzi, isteresi 0,25 V
.model SWK SW(RON=0.1 ROFF=1e12 VT=0.5 VH=0.25)
VK1I NK1I 0 DC 0
VK1T NK1T 0 DC 1000
BK1R SK1R 0 V = (1 - V(NK1I)) * pwl(time - V(NK1T), -1e4,0, 0,0, 1u,1, 150u,1, 151u,0, 300u,0, 301u,1, 450u,1, 451u,0, 520u,0, 521u,1, 1e4,1)
+ + V(NK1I) * pwl(time - V(NK1T), -1e4,1, 0,1, 1u,0, 400u,0, 401u,1, 600u,1, 601u,0, 1e4,0)
SK1 RGB 0 SK1R 0 SWK
VK5I NK5I 0 DC 0
VK5T NK5T 0 DC 1000
BK5R SK5R 0 V = (1 - V(NK5I)) * pwl(time - V(NK5T), -1e4,0, 0,0, 1u,1, 150u,1, 151u,0, 300u,0, 301u,1, 450u,1, 451u,0, 520u,0, 521u,1, 1e4,1)
+ + V(NK5I) * pwl(time - V(NK5T), -1e4,1, 0,1, 1u,0, 400u,0, 401u,1, 600u,1, 601u,0, 1e4,0)
SK5 RG10B 0 SK5R 0 SWK
* ---- L29d: il contatto in serie al jack e la derivazione lato condensatore ----
VKSA NKSA 0 DC 1000
VKSB NKSB 0 DC 2000
BKSR NKSR 0 V = pwl(time - V(NKSA), -1e4,1, 0,1, 1u,0, 400u,0, 401u,1, 600u,1, 601u,0, 1e4,0) + pwl(time - V(NKSB), -1e4,0, 0,0, 1u,1, 150u,1, 151u,0, 300u,0, 301u,1, 450u,1, 451u,0, 520u,0, 521u,1, 1e4,1)
VKCA NKCA 0 DC 1000
VKCB NKCB 0 DC 2000
BKCR NKCR 0 V = pwl(time - V(NKCA), -1e4,0, 0,0, 1u,1, 150u,1, 151u,0, 300u,0, 301u,1, 450u,1, 451u,0, 520u,0, 521u,1, 1e4,1) + pwl(time - V(NKCB), -1e4,1, 0,1, 1u,0, 400u,0, 401u,1, 600u,1, 601u,0, 1e4,0) - 1
SKSM MAINC MAINJACK NKSR 0 SWK
CKSM MAINC MAINJACK 0.1p
SKCM MAINC 0 NKCR 0 SWK
CCAVM MAINJACK 0 1e-18
SKS1 FIXC1 FIXJACK1 NKSR 0 SWK
CKS1 FIXC1 FIXJACK1 0.1p
SKC1 FIXC1 0 NKCR 0 SWK
CCAV1 FIXJACK1 0 1e-18
SKS2 FIXC2 FIXJACK2 NKSR 0 SWK
CKS2 FIXC2 FIXJACK2 0.1p
SKC2 FIXC2 0 NKCR 0 SWK
CCAV2 FIXJACK2 0 1e-18

* ---- L29c: il trim (ADR-027, trim.py candidato 2) fra OUTA e l'attenuatore ----
* RATTT del blocco si apre nel .control (alter rattt = 1e12): OUTA arriva a W da qui.
RL1 OUTA TAP6 845
RL2 TAP6 TAP12 464
RL3 TAP12 0 464
VT1RI NT1RI 0 DC 0
VT1RT NT1RT 0 DC 1000
BT1RR ST1RR 0 V = (1 - V(NT1RI)) * pwl(time - V(NT1RT), -1e4,0, 0,0, 1u,1, 150u,1, 151u,0, 300u,0, 301u,1, 450u,1, 451u,0, 520u,0, 521u,1, 1e4,1)
+ + V(NT1RI) * pwl(time - V(NT1RT), -1e4,1, 0,1, 1u,0, 400u,0, 401u,1, 600u,1, 601u,0, 1e4,0)
ST1R OUTA ATOP ST1RR 0 SWK
CT1RP OUTA ATOP 15p
RT1RP OUTA ATOP 1G
VT1SI NT1SI 0 DC 0
VT1ST NT1ST 0 DC 1000
BT1SR ST1SR 0 V = (1 - V(NT1SI)) * pwl(time - V(NT1ST), -1e4,0, 0,0, 1u,1, 150u,1, 151u,0, 300u,0, 301u,1, 450u,1, 451u,0, 520u,0, 521u,1, 1e4,1)
+ + V(NT1SI) * pwl(time - V(NT1ST), -1e4,1, 0,1, 1u,0, 400u,0, 401u,1, 600u,1, 601u,0, 1e4,0)
ST1S T2C ATOP ST1SR 0 SWK
CT1SP T2C ATOP 15p
RT1SP T2C ATOP 1G
VT2RI NT2RI 0 DC 0
VT2RT NT2RT 0 DC 1000
BT2RR ST2RR 0 V = (1 - V(NT2RI)) * pwl(time - V(NT2RT), -1e4,0, 0,0, 1u,1, 150u,1, 151u,0, 300u,0, 301u,1, 450u,1, 451u,0, 520u,0, 521u,1, 1e4,1)
+ + V(NT2RI) * pwl(time - V(NT2RT), -1e4,1, 0,1, 1u,0, 400u,0, 401u,1, 600u,1, 601u,0, 1e4,0)
ST2R TAP6 T2C ST2RR 0 SWK
CT2RP TAP6 T2C 15p
RT2RP TAP6 T2C 1G
VT2SI NT2SI 0 DC 0
VT2ST NT2ST 0 DC 1000
BT2SR ST2SR 0 V = (1 - V(NT2SI)) * pwl(time - V(NT2ST), -1e4,0, 0,0, 1u,1, 150u,1, 151u,0, 300u,0, 301u,1, 450u,1, 451u,0, 520u,0, 521u,1, 1e4,1)
+ + V(NT2SI) * pwl(time - V(NT2ST), -1e4,1, 0,1, 1u,0, 400u,0, 401u,1, 600u,1, 601u,0, 1e4,0)
ST2S TAP12 T2C ST2SR 0 SWK
CT2SP TAP12 T2C 15p
RT2SP TAP12 T2C 1G
CWIRE ATOP 0 100p
RATTH ATOP W 1m
* ---- L29c: la sonda del gruppo B (limitations #29), su nodi propri (#24) ----
VPRBD PRBD 0 DC 15
VPRBG PRBG 0 DC 0
JPRB PRBD PRBG 0 LSK489A
* ---- L29c: l'alimentazione del comando dei LED, 0..1, segue il rail positivo ----
VPWL NPWL 0 DC 1
* ---- L29c: il punto di partenza di Newton per l'op (limitations #33) ----
* Con l'interruttore del trim fra OUTA e W il blocco A ha una seconda soluzione in continua,
* agganciata al rail (+13 V): gmin e source stepping falliscono e il 'transient op' finisce
* li', 'successfully'. Il nodeset e' solo il primo tentativo di Newton: la soluzione resta
* una soluzione del circuito, e ridà quella del deck di main (sonde/op/, controfattuale).
.nodeset V(OUTA)=0 V(W)=0 V(ATOP)=0 V(OUTB)=0 V(MAIN_A)=0 V(OUTF1)=0 V(OUTF2)=0

.control
* limitations #30: il tempo a 16 cifre, prima di ogni wrdata
set numdgt=15
set d = .dat
* L29c: corri.sh rifiuta ogni corsa col 'Transient op' nel log (limitations #33).
save v(mainjack) v(fixjack1) v(fixjack2) v(xls.xs) v(xlp.xs) v(dep) v(ina) v(vplus) v(vminus) v(main_a) v(mainc) v(fixc1) v(fixc2)
echo "cella,file,variante,f_hz,amp,gm,rl,t_ins,t_rel,t_fine,tmax,tipo,rif_ins,rif_rel,t_grad,gruppo,conta" > tb_v2_casopeggiore_manifest.csv
* la sorgente passa dalla LDR in serie: RSRC del blocco a 1 T, il selettore chiuso
alter rsrc = 1e12
alter vphs dc = 1.5707963267948966
alter vmhjk dc = 1
* il trim porta OUTA all'attenuatore: RATTT del blocco aperto
alter rattt = 1e12
* ---- L29d2_iii: riferimenti 1k ----
alter vamp dc = 3.818
alter vfrq dc = 1000
alter rldm = 100k
alter rld1 = 100k
alter rld2 = 100k
alter vti dc = 1000
alter vtr dc = 2000
alter vtijk dc = 1000
alter vtrjk dc = 2000
alter vosa dc = 0
alter vosb dc = 0
alter vosf1 dc = 0
alter vosf2 dc = 0
alter ratth = 1m
alter rattb = 10k
alter rl1 = 845
alter cwire = 100p
alter vk1i dc = 1
alter vk1t dc = 1000.000000
alter vk5i dc = 1
alter vk5t dc = 1000.000000
alter vt1ri dc = 1
alter vt1rt dc = 1000.000000
alter vt1si dc = 0
alter vt1st dc = 1000.000000
alter vt2ri dc = 1
alter vt2rt dc = 1000.000000
alter vt2si dc = 0
alter vt2st dc = 1000.000000
alter vtijk dc = 1000.000000
alter vtrjk dc = 2000.000000
alter vksa dc = 1000.000000
alter vksb dc = 2000.001000
alter vkca dc = 1000.001000
alter vkcb dc = 2000.000000
alter vtiser dc = -10
alter vtrser dc = 1000
alter rbym = 1e12
alter rby1 = 1e12
alter rby2 = 1e12
alter rbcm = 220k
alter rbc1 = 470k
alter rbc2 = 470k
alter cksm = 0.1p
alter cks1 = 0.1p
alter cks2 = 0.1p
alter ccavm = 1e-18
alter ccav1 = 1e-18
alter ccav2 = 1e-18
print @cksm[capacitance] @cks1[capacitance] @cks2[capacitance] @ccavm[capacitance] @ccav1[capacitance] @ccav2[capacitance]
tran 1e-05 36.5 0 1e-05
wrdata g10mai_1k_iii$d v(mainjack) v(fixjack1) v(fixjack2)
wrdata g10mai_1k_iii_stati$d v(xls.xs) v(xlp.xs) v(dep) v(ina) v(vplus) v(vminus) v(main_a) v(mainc) v(fixc1) v(fixc2)
destroy all
echo "g10mai_1k_iii,g10mai_1k_iii.dat,rif,1000,3.818,10,100k,1.0,8.5,36.5,1e-05,rif_mai,-,-,0.0,0," >> tb_v2_casopeggiore_manifest.csv
alter vamp dc = 3.818
alter vfrq dc = 1000
alter rldm = 100k
alter rld1 = 100k
alter rld2 = 100k
alter vti dc = -10
alter vtr dc = 1000
alter vtijk dc = -10
alter vtrjk dc = 1000
alter vosa dc = 0
alter vosb dc = 0
alter vosf1 dc = 0
alter vosf2 dc = 0
alter ratth = 1m
alter rattb = 10k
alter rl1 = 845
alter cwire = 100p
alter vk1i dc = 1
alter vk1t dc = 1000.000000
alter vk5i dc = 1
alter vk5t dc = 1000.000000
alter vt1ri dc = 1
alter vt1rt dc = 1000.000000
alter vt1si dc = 0
alter vt1st dc = 1000.000000
alter vt2ri dc = 1
alter vt2rt dc = 1000.000000
alter vt2si dc = 0
alter vt2st dc = 1000.000000
alter vtijk dc = 1000.000000
alter vtrjk dc = 2000.000000
alter vksa dc = -10.000000
alter vksb dc = 1000.001000
alter vkca dc = -9.999000
alter vkcb dc = 1000.000000
alter vtiser dc = -10
alter vtrser dc = 1000
alter rbym = 1e12
alter rby1 = 1e12
alter rby2 = 1e12
alter rbcm = 220k
alter rbc1 = 470k
alter rbc2 = 470k
alter cksm = 0.1p
alter cks1 = 0.1p
alter cks2 = 0.1p
alter ccavm = 1e-18
alter ccav1 = 1e-18
alter ccav2 = 1e-18
print @cksm[capacitance] @cks1[capacitance] @cks2[capacitance] @ccavm[capacitance] @ccav1[capacitance] @ccav2[capacitance]
tran 1e-05 36.5 0 1e-05
wrdata g10sempre_1k_iii$d v(mainjack) v(fixjack1) v(fixjack2)
wrdata g10sempre_1k_iii_stati$d v(xls.xs) v(xlp.xs) v(dep) v(ina) v(vplus) v(vminus) v(main_a) v(mainc) v(fixc1) v(fixc2)
destroy all
echo "g10sempre_1k_iii,g10sempre_1k_iii.dat,rif,1000,3.818,10,100k,1.0,8.5,36.5,1e-05,rif_sempre,-,-,0.0,0," >> tb_v2_casopeggiore_manifest.csv
alter vamp dc = 3.818
alter vfrq dc = 1000
alter rldm = 100k
alter rld1 = 100k
alter rld2 = 100k
alter vti dc = 1000
alter vtr dc = 2000
alter vtijk dc = 1000
alter vtrjk dc = 2000
alter vosa dc = 0
alter vosb dc = 0
alter vosf1 dc = 0
alter vosf2 dc = 0
alter ratth = 1m
alter rattb = 10k
alter rl1 = 845
alter cwire = 100p
alter vk1i dc = 0
alter vk1t dc = 1000.000000
alter vk5i dc = 0
alter vk5t dc = 1000.000000
alter vt1ri dc = 1
alter vt1rt dc = 1000.000000
alter vt1si dc = 0
alter vt1st dc = 1000.000000
alter vt2ri dc = 1
alter vt2rt dc = 1000.000000
alter vt2si dc = 0
alter vt2st dc = 1000.000000
alter vtijk dc = 1000.000000
alter vtrjk dc = 2000.000000
alter vksa dc = 1000.000000
alter vksb dc = 2000.001000
alter vkca dc = 1000.001000
alter vkcb dc = 2000.000000
alter vtiser dc = -10
alter vtrser dc = 1000
alter rbym = 1e12
alter rby1 = 1e12
alter rby2 = 1e12
alter rbcm = 220k
alter rbc1 = 470k
alter rbc2 = 470k
alter cksm = 0.1p
alter cks1 = 0.1p
alter cks2 = 0.1p
alter ccavm = 1e-18
alter ccav1 = 1e-18
alter ccav2 = 1e-18
print @cksm[capacitance] @cks1[capacitance] @cks2[capacitance] @ccavm[capacitance] @ccav1[capacitance] @ccav2[capacitance]
tran 1e-05 19.0 0 1e-05
wrdata g0mai_1k_iii$d v(mainjack) v(fixjack1) v(fixjack2)
wrdata g0mai_1k_iii_stati$d v(xls.xs) v(xlp.xs) v(dep) v(ina) v(vplus) v(vminus) v(main_a) v(mainc) v(fixc1) v(fixc2)
destroy all
echo "g0mai_1k_iii,g0mai_1k_iii.dat,rif,1000,3.818,0,100k,1.0,8.5,19.0,1e-05,rif_mai,-,-,0.0,0," >> tb_v2_casopeggiore_manifest.csv
alter vamp dc = 3.818
alter vfrq dc = 1000
alter rldm = 100k
alter rld1 = 100k
alter rld2 = 100k
alter vti dc = -10
alter vtr dc = 1000
alter vtijk dc = -10
alter vtrjk dc = 1000
alter vosa dc = 0
alter vosb dc = 0
alter vosf1 dc = 0
alter vosf2 dc = 0
alter ratth = 1m
alter rattb = 10k
alter rl1 = 845
alter cwire = 100p
alter vk1i dc = 0
alter vk1t dc = 1000.000000
alter vk5i dc = 0
alter vk5t dc = 1000.000000
alter vt1ri dc = 1
alter vt1rt dc = 1000.000000
alter vt1si dc = 0
alter vt1st dc = 1000.000000
alter vt2ri dc = 1
alter vt2rt dc = 1000.000000
alter vt2si dc = 0
alter vt2st dc = 1000.000000
alter vtijk dc = 1000.000000
alter vtrjk dc = 2000.000000
alter vksa dc = -10.000000
alter vksb dc = 1000.001000
alter vkca dc = -9.999000
alter vkcb dc = 1000.000000
alter vtiser dc = -10
alter vtrser dc = 1000
alter rbym = 1e12
alter rby1 = 1e12
alter rby2 = 1e12
alter rbcm = 220k
alter rbc1 = 470k
alter rbc2 = 470k
alter cksm = 0.1p
alter cks1 = 0.1p
alter cks2 = 0.1p
alter ccavm = 1e-18
alter ccav1 = 1e-18
alter ccav2 = 1e-18
print @cksm[capacitance] @cks1[capacitance] @cks2[capacitance] @ccavm[capacitance] @ccav1[capacitance] @ccav2[capacitance]
tran 1e-05 19.0 0 1e-05
wrdata g0sempre_1k_iii$d v(mainjack) v(fixjack1) v(fixjack2)
wrdata g0sempre_1k_iii_stati$d v(xls.xs) v(xlp.xs) v(dep) v(ina) v(vplus) v(vminus) v(main_a) v(mainc) v(fixc1) v(fixc2)
destroy all
echo "g0sempre_1k_iii,g0sempre_1k_iii.dat,rif,1000,3.818,0,100k,1.0,8.5,19.0,1e-05,rif_sempre,-,-,0.0,0," >> tb_v2_casopeggiore_manifest.csv
alter vamp dc = 3.818
alter vfrq dc = 1000
alter rldm = 100k
alter rld1 = 100k
alter rld2 = 100k
alter vti dc = 1000
alter vtr dc = 2000
alter vtijk dc = 1000
alter vtrjk dc = 2000
alter vosa dc = 0
alter vosb dc = 0
alter vosf1 dc = 0
alter vosf2 dc = 0
alter ratth = 1m
alter rattb = 10k
alter rl1 = 845
alter cwire = 100p
alter vk1i dc = 1
alter vk1t dc = 1000.000000
alter vk5i dc = 0
alter vk5t dc = 1000.000000
alter vt1ri dc = 1
alter vt1rt dc = 1000.000000
alter vt1si dc = 0
alter vt1st dc = 1000.000000
alter vt2ri dc = 1
alter vt2rt dc = 1000.000000
alter vt2si dc = 0
alter vt2st dc = 1000.000000
alter vtijk dc = 1000.000000
alter vtrjk dc = 2000.000000
alter vksa dc = 1000.000000
alter vksb dc = 2000.001000
alter vkca dc = 1000.001000
alter vkcb dc = 2000.000000
alter vtiser dc = -10
alter vtrser dc = 1000
alter rbym = 1e12
alter rby1 = 1e12
alter rby2 = 1e12
alter rbcm = 220k
alter rbc1 = 470k
alter rbc2 = 470k
alter cksm = 0.1p
alter cks1 = 0.1p
alter cks2 = 0.1p
alter ccavm = 1e-18
alter ccav1 = 1e-18
alter ccav2 = 1e-18
print @cksm[capacitance] @cks1[capacitance] @cks2[capacitance] @ccavm[capacitance] @ccav1[capacitance] @ccav2[capacitance]
tran 1e-05 19.0 0 1e-05
wrdata g3mai_1k_iii$d v(mainjack) v(fixjack1) v(fixjack2)
wrdata g3mai_1k_iii_stati$d v(xls.xs) v(xlp.xs) v(dep) v(ina) v(vplus) v(vminus) v(main_a) v(mainc) v(fixc1) v(fixc2)
destroy all
echo "g3mai_1k_iii,g3mai_1k_iii.dat,rif,1000,3.818,3,100k,1.0,8.5,19.0,1e-05,rif_mai,-,-,0.0,0," >> tb_v2_casopeggiore_manifest.csv
alter vamp dc = 3.818
alter vfrq dc = 1000
alter rldm = 100k
alter rld1 = 100k
alter rld2 = 100k
alter vti dc = -10
alter vtr dc = 1000
alter vtijk dc = -10
alter vtrjk dc = 1000
alter vosa dc = 0
alter vosb dc = 0
alter vosf1 dc = 0
alter vosf2 dc = 0
alter ratth = 1m
alter rattb = 10k
alter rl1 = 845
alter cwire = 100p
alter vk1i dc = 1
alter vk1t dc = 1000.000000
alter vk5i dc = 0
alter vk5t dc = 1000.000000
alter vt1ri dc = 1
alter vt1rt dc = 1000.000000
alter vt1si dc = 0
alter vt1st dc = 1000.000000
alter vt2ri dc = 1
alter vt2rt dc = 1000.000000
alter vt2si dc = 0
alter vt2st dc = 1000.000000
alter vtijk dc = 1000.000000
alter vtrjk dc = 2000.000000
alter vksa dc = -10.000000
alter vksb dc = 1000.001000
alter vkca dc = -9.999000
alter vkcb dc = 1000.000000
alter vtiser dc = -10
alter vtrser dc = 1000
alter rbym = 1e12
alter rby1 = 1e12
alter rby2 = 1e12
alter rbcm = 220k
alter rbc1 = 470k
alter rbc2 = 470k
alter cksm = 0.1p
alter cks1 = 0.1p
alter cks2 = 0.1p
alter ccavm = 1e-18
alter ccav1 = 1e-18
alter ccav2 = 1e-18
print @cksm[capacitance] @cks1[capacitance] @cks2[capacitance] @ccavm[capacitance] @ccav1[capacitance] @ccav2[capacitance]
tran 1e-05 19.0 0 1e-05
wrdata g3sempre_1k_iii$d v(mainjack) v(fixjack1) v(fixjack2)
wrdata g3sempre_1k_iii_stati$d v(xls.xs) v(xlp.xs) v(dep) v(ina) v(vplus) v(vminus) v(main_a) v(mainc) v(fixc1) v(fixc2)
destroy all
echo "g3sempre_1k_iii,g3sempre_1k_iii.dat,rif,1000,3.818,3,100k,1.0,8.5,19.0,1e-05,rif_sempre,-,-,0.0,0," >> tb_v2_casopeggiore_manifest.csv
* ---- L29d2_iii: riferimenti 20 ----
alter vamp dc = 3.818
alter vfrq dc = 20
alter rldm = 100k
alter rld1 = 100k
alter rld2 = 100k
alter vti dc = 1000
alter vtr dc = 2000
alter vtijk dc = 1000
alter vtrjk dc = 2000
alter vosa dc = 0
alter vosb dc = 0
alter vosf1 dc = 0
alter vosf2 dc = 0
alter ratth = 1m
alter rattb = 10k
alter rl1 = 845
alter cwire = 100p
alter vk1i dc = 1
alter vk1t dc = 1000.000000
alter vk5i dc = 1
alter vk5t dc = 1000.000000
alter vt1ri dc = 1
alter vt1rt dc = 1000.000000
alter vt1si dc = 0
alter vt1st dc = 1000.000000
alter vt2ri dc = 1
alter vt2rt dc = 1000.000000
alter vt2si dc = 0
alter vt2st dc = 1000.000000
alter vtijk dc = 1000.000000
alter vtrjk dc = 2000.000000
alter vksa dc = 1000.000000
alter vksb dc = 2000.001000
alter vkca dc = 1000.001000
alter vkcb dc = 2000.000000
alter vtiser dc = -10
alter vtrser dc = 1000
alter rbym = 1e12
alter rby1 = 1e12
alter rby2 = 1e12
alter rbcm = 220k
alter rbc1 = 470k
alter rbc2 = 470k
alter cksm = 0.1p
alter cks1 = 0.1p
alter cks2 = 0.1p
alter ccavm = 1e-18
alter ccav1 = 1e-18
alter ccav2 = 1e-18
print @cksm[capacitance] @cks1[capacitance] @cks2[capacitance] @ccavm[capacitance] @ccav1[capacitance] @ccav2[capacitance]
tran 1e-05 36.5 0 1e-05
wrdata g10mai_20_iii$d v(mainjack) v(fixjack1) v(fixjack2)
wrdata g10mai_20_iii_stati$d v(xls.xs) v(xlp.xs) v(dep) v(ina) v(vplus) v(vminus) v(main_a) v(mainc) v(fixc1) v(fixc2)
destroy all
echo "g10mai_20_iii,g10mai_20_iii.dat,rif,20,3.818,10,100k,1.0,8.5,36.5,1e-05,rif_mai,-,-,0.0,0," >> tb_v2_casopeggiore_manifest.csv
alter vamp dc = 3.818
alter vfrq dc = 20
alter rldm = 100k
alter rld1 = 100k
alter rld2 = 100k
alter vti dc = -10
alter vtr dc = 1000
alter vtijk dc = -10
alter vtrjk dc = 1000
alter vosa dc = 0
alter vosb dc = 0
alter vosf1 dc = 0
alter vosf2 dc = 0
alter ratth = 1m
alter rattb = 10k
alter rl1 = 845
alter cwire = 100p
alter vk1i dc = 1
alter vk1t dc = 1000.000000
alter vk5i dc = 1
alter vk5t dc = 1000.000000
alter vt1ri dc = 1
alter vt1rt dc = 1000.000000
alter vt1si dc = 0
alter vt1st dc = 1000.000000
alter vt2ri dc = 1
alter vt2rt dc = 1000.000000
alter vt2si dc = 0
alter vt2st dc = 1000.000000
alter vtijk dc = 1000.000000
alter vtrjk dc = 2000.000000
alter vksa dc = -10.000000
alter vksb dc = 1000.001000
alter vkca dc = -9.999000
alter vkcb dc = 1000.000000
alter vtiser dc = -10
alter vtrser dc = 1000
alter rbym = 1e12
alter rby1 = 1e12
alter rby2 = 1e12
alter rbcm = 220k
alter rbc1 = 470k
alter rbc2 = 470k
alter cksm = 0.1p
alter cks1 = 0.1p
alter cks2 = 0.1p
alter ccavm = 1e-18
alter ccav1 = 1e-18
alter ccav2 = 1e-18
print @cksm[capacitance] @cks1[capacitance] @cks2[capacitance] @ccavm[capacitance] @ccav1[capacitance] @ccav2[capacitance]
tran 1e-05 36.5 0 1e-05
wrdata g10sempre_20_iii$d v(mainjack) v(fixjack1) v(fixjack2)
wrdata g10sempre_20_iii_stati$d v(xls.xs) v(xlp.xs) v(dep) v(ina) v(vplus) v(vminus) v(main_a) v(mainc) v(fixc1) v(fixc2)
destroy all
echo "g10sempre_20_iii,g10sempre_20_iii.dat,rif,20,3.818,10,100k,1.0,8.5,36.5,1e-05,rif_sempre,-,-,0.0,0," >> tb_v2_casopeggiore_manifest.csv
alter vamp dc = 3.818
alter vfrq dc = 20
alter rldm = 100k
alter rld1 = 100k
alter rld2 = 100k
alter vti dc = 1000
alter vtr dc = 2000
alter vtijk dc = 1000
alter vtrjk dc = 2000
alter vosa dc = 0
alter vosb dc = 0
alter vosf1 dc = 0
alter vosf2 dc = 0
alter ratth = 1m
alter rattb = 10k
alter rl1 = 845
alter cwire = 100p
alter vk1i dc = 0
alter vk1t dc = 1000.000000
alter vk5i dc = 0
alter vk5t dc = 1000.000000
alter vt1ri dc = 1
alter vt1rt dc = 1000.000000
alter vt1si dc = 0
alter vt1st dc = 1000.000000
alter vt2ri dc = 1
alter vt2rt dc = 1000.000000
alter vt2si dc = 0
alter vt2st dc = 1000.000000
alter vtijk dc = 1000.000000
alter vtrjk dc = 2000.000000
alter vksa dc = 1000.000000
alter vksb dc = 2000.001000
alter vkca dc = 1000.001000
alter vkcb dc = 2000.000000
alter vtiser dc = -10
alter vtrser dc = 1000
alter rbym = 1e12
alter rby1 = 1e12
alter rby2 = 1e12
alter rbcm = 220k
alter rbc1 = 470k
alter rbc2 = 470k
alter cksm = 0.1p
alter cks1 = 0.1p
alter cks2 = 0.1p
alter ccavm = 1e-18
alter ccav1 = 1e-18
alter ccav2 = 1e-18
print @cksm[capacitance] @cks1[capacitance] @cks2[capacitance] @ccavm[capacitance] @ccav1[capacitance] @ccav2[capacitance]
tran 1e-05 19.0 0 1e-05
wrdata g0mai_20_iii$d v(mainjack) v(fixjack1) v(fixjack2)
wrdata g0mai_20_iii_stati$d v(xls.xs) v(xlp.xs) v(dep) v(ina) v(vplus) v(vminus) v(main_a) v(mainc) v(fixc1) v(fixc2)
destroy all
echo "g0mai_20_iii,g0mai_20_iii.dat,rif,20,3.818,0,100k,1.0,8.5,19.0,1e-05,rif_mai,-,-,0.0,0," >> tb_v2_casopeggiore_manifest.csv
alter vamp dc = 3.818
alter vfrq dc = 20
alter rldm = 100k
alter rld1 = 100k
alter rld2 = 100k
alter vti dc = -10
alter vtr dc = 1000
alter vtijk dc = -10
alter vtrjk dc = 1000
alter vosa dc = 0
alter vosb dc = 0
alter vosf1 dc = 0
alter vosf2 dc = 0
alter ratth = 1m
alter rattb = 10k
alter rl1 = 845
alter cwire = 100p
alter vk1i dc = 0
alter vk1t dc = 1000.000000
alter vk5i dc = 0
alter vk5t dc = 1000.000000
alter vt1ri dc = 1
alter vt1rt dc = 1000.000000
alter vt1si dc = 0
alter vt1st dc = 1000.000000
alter vt2ri dc = 1
alter vt2rt dc = 1000.000000
alter vt2si dc = 0
alter vt2st dc = 1000.000000
alter vtijk dc = 1000.000000
alter vtrjk dc = 2000.000000
alter vksa dc = -10.000000
alter vksb dc = 1000.001000
alter vkca dc = -9.999000
alter vkcb dc = 1000.000000
alter vtiser dc = -10
alter vtrser dc = 1000
alter rbym = 1e12
alter rby1 = 1e12
alter rby2 = 1e12
alter rbcm = 220k
alter rbc1 = 470k
alter rbc2 = 470k
alter cksm = 0.1p
alter cks1 = 0.1p
alter cks2 = 0.1p
alter ccavm = 1e-18
alter ccav1 = 1e-18
alter ccav2 = 1e-18
print @cksm[capacitance] @cks1[capacitance] @cks2[capacitance] @ccavm[capacitance] @ccav1[capacitance] @ccav2[capacitance]
tran 1e-05 19.0 0 1e-05
wrdata g0sempre_20_iii$d v(mainjack) v(fixjack1) v(fixjack2)
wrdata g0sempre_20_iii_stati$d v(xls.xs) v(xlp.xs) v(dep) v(ina) v(vplus) v(vminus) v(main_a) v(mainc) v(fixc1) v(fixc2)
destroy all
echo "g0sempre_20_iii,g0sempre_20_iii.dat,rif,20,3.818,0,100k,1.0,8.5,19.0,1e-05,rif_sempre,-,-,0.0,0," >> tb_v2_casopeggiore_manifest.csv
alter vamp dc = 3.818
alter vfrq dc = 20
alter rldm = 100k
alter rld1 = 100k
alter rld2 = 100k
alter vti dc = 1000
alter vtr dc = 2000
alter vtijk dc = 1000
alter vtrjk dc = 2000
alter vosa dc = 0
alter vosb dc = 0
alter vosf1 dc = 0
alter vosf2 dc = 0
alter ratth = 1m
alter rattb = 10k
alter rl1 = 845
alter cwire = 100p
alter vk1i dc = 1
alter vk1t dc = 1000.000000
alter vk5i dc = 0
alter vk5t dc = 1000.000000
alter vt1ri dc = 1
alter vt1rt dc = 1000.000000
alter vt1si dc = 0
alter vt1st dc = 1000.000000
alter vt2ri dc = 1
alter vt2rt dc = 1000.000000
alter vt2si dc = 0
alter vt2st dc = 1000.000000
alter vtijk dc = 1000.000000
alter vtrjk dc = 2000.000000
alter vksa dc = 1000.000000
alter vksb dc = 2000.001000
alter vkca dc = 1000.001000
alter vkcb dc = 2000.000000
alter vtiser dc = -10
alter vtrser dc = 1000
alter rbym = 1e12
alter rby1 = 1e12
alter rby2 = 1e12
alter rbcm = 220k
alter rbc1 = 470k
alter rbc2 = 470k
alter cksm = 0.1p
alter cks1 = 0.1p
alter cks2 = 0.1p
alter ccavm = 1e-18
alter ccav1 = 1e-18
alter ccav2 = 1e-18
print @cksm[capacitance] @cks1[capacitance] @cks2[capacitance] @ccavm[capacitance] @ccav1[capacitance] @ccav2[capacitance]
tran 1e-05 19.0 0 1e-05
wrdata g3mai_20_iii$d v(mainjack) v(fixjack1) v(fixjack2)
wrdata g3mai_20_iii_stati$d v(xls.xs) v(xlp.xs) v(dep) v(ina) v(vplus) v(vminus) v(main_a) v(mainc) v(fixc1) v(fixc2)
destroy all
echo "g3mai_20_iii,g3mai_20_iii.dat,rif,20,3.818,3,100k,1.0,8.5,19.0,1e-05,rif_mai,-,-,0.0,0," >> tb_v2_casopeggiore_manifest.csv
alter vamp dc = 3.818
alter vfrq dc = 20
alter rldm = 100k
alter rld1 = 100k
alter rld2 = 100k
alter vti dc = -10
alter vtr dc = 1000
alter vtijk dc = -10
alter vtrjk dc = 1000
alter vosa dc = 0
alter vosb dc = 0
alter vosf1 dc = 0
alter vosf2 dc = 0
alter ratth = 1m
alter rattb = 10k
alter rl1 = 845
alter cwire = 100p
alter vk1i dc = 1
alter vk1t dc = 1000.000000
alter vk5i dc = 0
alter vk5t dc = 1000.000000
alter vt1ri dc = 1
alter vt1rt dc = 1000.000000
alter vt1si dc = 0
alter vt1st dc = 1000.000000
alter vt2ri dc = 1
alter vt2rt dc = 1000.000000
alter vt2si dc = 0
alter vt2st dc = 1000.000000
alter vtijk dc = 1000.000000
alter vtrjk dc = 2000.000000
alter vksa dc = -10.000000
alter vksb dc = 1000.001000
alter vkca dc = -9.999000
alter vkcb dc = 1000.000000
alter vtiser dc = -10
alter vtrser dc = 1000
alter rbym = 1e12
alter rby1 = 1e12
alter rby2 = 1e12
alter rbcm = 220k
alter rbc1 = 470k
alter rbc2 = 470k
alter cksm = 0.1p
alter cks1 = 0.1p
alter cks2 = 0.1p
alter ccavm = 1e-18
alter ccav1 = 1e-18
alter ccav2 = 1e-18
print @cksm[capacitance] @cks1[capacitance] @cks2[capacitance] @ccavm[capacitance] @ccav1[capacitance] @ccav2[capacitance]
tran 1e-05 19.0 0 1e-05
wrdata g3sempre_20_iii$d v(mainjack) v(fixjack1) v(fixjack2)
wrdata g3sempre_20_iii_stati$d v(xls.xs) v(xlp.xs) v(dep) v(ina) v(vplus) v(vminus) v(main_a) v(mainc) v(fixc1) v(fixc2)
destroy all
echo "g3sempre_20_iii,g3sempre_20_iii.dat,rif,20,3.818,3,100k,1.0,8.5,19.0,1e-05,rif_sempre,-,-,0.0,0," >> tb_v2_casopeggiore_manifest.csv
* ---- L29d2_iii: riferimenti senza segnale ----
alter vamp dc = 0
alter vfrq dc = 1000
alter rldm = 100k
alter rld1 = 100k
alter rld2 = 100k
alter vti dc = 1000
alter vtr dc = 2000
alter vtijk dc = 1000
alter vtrjk dc = 2000
alter vosa dc = 0
alter vosb dc = 0
alter vosf1 dc = 0
alter vosf2 dc = 0
alter ratth = 1m
alter rattb = 10k
alter rl1 = 845
alter cwire = 100p
alter vk1i dc = 1
alter vk1t dc = 1000.000000
alter vk5i dc = 1
alter vk5t dc = 1000.000000
alter vt1ri dc = 1
alter vt1rt dc = 1000.000000
alter vt1si dc = 0
alter vt1st dc = 1000.000000
alter vt2ri dc = 1
alter vt2rt dc = 1000.000000
alter vt2si dc = 0
alter vt2st dc = 1000.000000
alter vtijk dc = 1000.000000
alter vtrjk dc = 2000.000000
alter vksa dc = 1000.000000
alter vksb dc = 2000.001000
alter vkca dc = 1000.001000
alter vkcb dc = 2000.000000
alter vtiser dc = -10
alter vtrser dc = 1000
alter rbym = 1e12
alter rby1 = 1e12
alter rby2 = 1e12
alter rbcm = 220k
alter rbc1 = 470k
alter rbc2 = 470k
alter cksm = 0.1p
alter cks1 = 0.1p
alter cks2 = 0.1p
alter ccavm = 1e-18
alter ccav1 = 1e-18
alter ccav2 = 1e-18
print @cksm[capacitance] @cks1[capacitance] @cks2[capacitance] @ccavm[capacitance] @ccav1[capacitance] @ccav2[capacitance]
tran 1e-05 36.5 0 1e-05
wrdata g10mai_lz_iii$d v(mainjack) v(fixjack1) v(fixjack2)
wrdata g10mai_lz_iii_stati$d v(xls.xs) v(xlp.xs) v(dep) v(ina) v(vplus) v(vminus) v(main_a) v(mainc) v(fixc1) v(fixc2)
destroy all
echo "g10mai_lz_iii,g10mai_lz_iii.dat,rif,1000,0,10,100k,1.0,8.5,36.5,1e-05,rif_mai,-,-,0.0,0," >> tb_v2_casopeggiore_manifest.csv
alter vamp dc = 0
alter vfrq dc = 1000
alter rldm = 100k
alter rld1 = 100k
alter rld2 = 100k
alter vti dc = -10
alter vtr dc = 1000
alter vtijk dc = -10
alter vtrjk dc = 1000
alter vosa dc = 0
alter vosb dc = 0
alter vosf1 dc = 0
alter vosf2 dc = 0
alter ratth = 1m
alter rattb = 10k
alter rl1 = 845
alter cwire = 100p
alter vk1i dc = 1
alter vk1t dc = 1000.000000
alter vk5i dc = 1
alter vk5t dc = 1000.000000
alter vt1ri dc = 1
alter vt1rt dc = 1000.000000
alter vt1si dc = 0
alter vt1st dc = 1000.000000
alter vt2ri dc = 1
alter vt2rt dc = 1000.000000
alter vt2si dc = 0
alter vt2st dc = 1000.000000
alter vtijk dc = 1000.000000
alter vtrjk dc = 2000.000000
alter vksa dc = -10.000000
alter vksb dc = 1000.001000
alter vkca dc = -9.999000
alter vkcb dc = 1000.000000
alter vtiser dc = -10
alter vtrser dc = 1000
alter rbym = 1e12
alter rby1 = 1e12
alter rby2 = 1e12
alter rbcm = 220k
alter rbc1 = 470k
alter rbc2 = 470k
alter cksm = 0.1p
alter cks1 = 0.1p
alter cks2 = 0.1p
alter ccavm = 1e-18
alter ccav1 = 1e-18
alter ccav2 = 1e-18
print @cksm[capacitance] @cks1[capacitance] @cks2[capacitance] @ccavm[capacitance] @ccav1[capacitance] @ccav2[capacitance]
tran 1e-05 36.5 0 1e-05
wrdata g10sempre_lz_iii$d v(mainjack) v(fixjack1) v(fixjack2)
wrdata g10sempre_lz_iii_stati$d v(xls.xs) v(xlp.xs) v(dep) v(ina) v(vplus) v(vminus) v(main_a) v(mainc) v(fixc1) v(fixc2)
destroy all
echo "g10sempre_lz_iii,g10sempre_lz_iii.dat,rif,1000,0,10,100k,1.0,8.5,36.5,1e-05,rif_sempre,-,-,0.0,0," >> tb_v2_casopeggiore_manifest.csv
alter vamp dc = 0
alter vfrq dc = 1000
alter rldm = 100k
alter rld1 = 100k
alter rld2 = 100k
alter vti dc = 1000
alter vtr dc = 2000
alter vtijk dc = 1000
alter vtrjk dc = 2000
alter vosa dc = 0
alter vosb dc = 0
alter vosf1 dc = 0
alter vosf2 dc = 0
alter ratth = 1m
alter rattb = 10k
alter rl1 = 845
alter cwire = 100p
alter vk1i dc = 0
alter vk1t dc = 1000.000000
alter vk5i dc = 0
alter vk5t dc = 1000.000000
alter vt1ri dc = 1
alter vt1rt dc = 1000.000000
alter vt1si dc = 0
alter vt1st dc = 1000.000000
alter vt2ri dc = 1
alter vt2rt dc = 1000.000000
alter vt2si dc = 0
alter vt2st dc = 1000.000000
alter vtijk dc = 1000.000000
alter vtrjk dc = 2000.000000
alter vksa dc = 1000.000000
alter vksb dc = 2000.001000
alter vkca dc = 1000.001000
alter vkcb dc = 2000.000000
alter vtiser dc = -10
alter vtrser dc = 1000
alter rbym = 1e12
alter rby1 = 1e12
alter rby2 = 1e12
alter rbcm = 220k
alter rbc1 = 470k
alter rbc2 = 470k
alter cksm = 0.1p
alter cks1 = 0.1p
alter cks2 = 0.1p
alter ccavm = 1e-18
alter ccav1 = 1e-18
alter ccav2 = 1e-18
print @cksm[capacitance] @cks1[capacitance] @cks2[capacitance] @ccavm[capacitance] @ccav1[capacitance] @ccav2[capacitance]
tran 1e-05 19.0 0 1e-05
wrdata g0mai_lz_iii$d v(mainjack) v(fixjack1) v(fixjack2)
wrdata g0mai_lz_iii_stati$d v(xls.xs) v(xlp.xs) v(dep) v(ina) v(vplus) v(vminus) v(main_a) v(mainc) v(fixc1) v(fixc2)
destroy all
echo "g0mai_lz_iii,g0mai_lz_iii.dat,rif,1000,0,0,100k,1.0,8.5,19.0,1e-05,rif_mai,-,-,0.0,0," >> tb_v2_casopeggiore_manifest.csv
alter vamp dc = 0
alter vfrq dc = 1000
alter rldm = 100k
alter rld1 = 100k
alter rld2 = 100k
alter vti dc = -10
alter vtr dc = 1000
alter vtijk dc = -10
alter vtrjk dc = 1000
alter vosa dc = 0
alter vosb dc = 0
alter vosf1 dc = 0
alter vosf2 dc = 0
alter ratth = 1m
alter rattb = 10k
alter rl1 = 845
alter cwire = 100p
alter vk1i dc = 0
alter vk1t dc = 1000.000000
alter vk5i dc = 0
alter vk5t dc = 1000.000000
alter vt1ri dc = 1
alter vt1rt dc = 1000.000000
alter vt1si dc = 0
alter vt1st dc = 1000.000000
alter vt2ri dc = 1
alter vt2rt dc = 1000.000000
alter vt2si dc = 0
alter vt2st dc = 1000.000000
alter vtijk dc = 1000.000000
alter vtrjk dc = 2000.000000
alter vksa dc = -10.000000
alter vksb dc = 1000.001000
alter vkca dc = -9.999000
alter vkcb dc = 1000.000000
alter vtiser dc = -10
alter vtrser dc = 1000
alter rbym = 1e12
alter rby1 = 1e12
alter rby2 = 1e12
alter rbcm = 220k
alter rbc1 = 470k
alter rbc2 = 470k
alter cksm = 0.1p
alter cks1 = 0.1p
alter cks2 = 0.1p
alter ccavm = 1e-18
alter ccav1 = 1e-18
alter ccav2 = 1e-18
print @cksm[capacitance] @cks1[capacitance] @cks2[capacitance] @ccavm[capacitance] @ccav1[capacitance] @ccav2[capacitance]
tran 1e-05 19.0 0 1e-05
wrdata g0sempre_lz_iii$d v(mainjack) v(fixjack1) v(fixjack2)
wrdata g0sempre_lz_iii_stati$d v(xls.xs) v(xlp.xs) v(dep) v(ina) v(vplus) v(vminus) v(main_a) v(mainc) v(fixc1) v(fixc2)
destroy all
echo "g0sempre_lz_iii,g0sempre_lz_iii.dat,rif,1000,0,0,100k,1.0,8.5,19.0,1e-05,rif_sempre,-,-,0.0,0," >> tb_v2_casopeggiore_manifest.csv
alter vamp dc = 0
alter vfrq dc = 1000
alter rldm = 100k
alter rld1 = 100k
alter rld2 = 100k
alter vti dc = 1000
alter vtr dc = 2000
alter vtijk dc = 1000
alter vtrjk dc = 2000
alter vosa dc = 0
alter vosb dc = 0
alter vosf1 dc = 0
alter vosf2 dc = 0
alter ratth = 1m
alter rattb = 10k
alter rl1 = 845
alter cwire = 100p
alter vk1i dc = 1
alter vk1t dc = 1000.000000
alter vk5i dc = 0
alter vk5t dc = 1000.000000
alter vt1ri dc = 1
alter vt1rt dc = 1000.000000
alter vt1si dc = 0
alter vt1st dc = 1000.000000
alter vt2ri dc = 1
alter vt2rt dc = 1000.000000
alter vt2si dc = 0
alter vt2st dc = 1000.000000
alter vtijk dc = 1000.000000
alter vtrjk dc = 2000.000000
alter vksa dc = 1000.000000
alter vksb dc = 2000.001000
alter vkca dc = 1000.001000
alter vkcb dc = 2000.000000
alter vtiser dc = -10
alter vtrser dc = 1000
alter rbym = 1e12
alter rby1 = 1e12
alter rby2 = 1e12
alter rbcm = 220k
alter rbc1 = 470k
alter rbc2 = 470k
alter cksm = 0.1p
alter cks1 = 0.1p
alter cks2 = 0.1p
alter ccavm = 1e-18
alter ccav1 = 1e-18
alter ccav2 = 1e-18
print @cksm[capacitance] @cks1[capacitance] @cks2[capacitance] @ccavm[capacitance] @ccav1[capacitance] @ccav2[capacitance]
tran 1e-05 19.0 0 1e-05
wrdata g3mai_lz_iii$d v(mainjack) v(fixjack1) v(fixjack2)
wrdata g3mai_lz_iii_stati$d v(xls.xs) v(xlp.xs) v(dep) v(ina) v(vplus) v(vminus) v(main_a) v(mainc) v(fixc1) v(fixc2)
destroy all
echo "g3mai_lz_iii,g3mai_lz_iii.dat,rif,1000,0,3,100k,1.0,8.5,19.0,1e-05,rif_mai,-,-,0.0,0," >> tb_v2_casopeggiore_manifest.csv
alter vamp dc = 0
alter vfrq dc = 1000
alter rldm = 100k
alter rld1 = 100k
alter rld2 = 100k
alter vti dc = -10
alter vtr dc = 1000
alter vtijk dc = -10
alter vtrjk dc = 1000
alter vosa dc = 0
alter vosb dc = 0
alter vosf1 dc = 0
alter vosf2 dc = 0
alter ratth = 1m
alter rattb = 10k
alter rl1 = 845
alter cwire = 100p
alter vk1i dc = 1
alter vk1t dc = 1000.000000
alter vk5i dc = 0
alter vk5t dc = 1000.000000
alter vt1ri dc = 1
alter vt1rt dc = 1000.000000
alter vt1si dc = 0
alter vt1st dc = 1000.000000
alter vt2ri dc = 1
alter vt2rt dc = 1000.000000
alter vt2si dc = 0
alter vt2st dc = 1000.000000
alter vtijk dc = 1000.000000
alter vtrjk dc = 2000.000000
alter vksa dc = -10.000000
alter vksb dc = 1000.001000
alter vkca dc = -9.999000
alter vkcb dc = 1000.000000
alter vtiser dc = -10
alter vtrser dc = 1000
alter rbym = 1e12
alter rby1 = 1e12
alter rby2 = 1e12
alter rbcm = 220k
alter rbc1 = 470k
alter rbc2 = 470k
alter cksm = 0.1p
alter cks1 = 0.1p
alter cks2 = 0.1p
alter ccavm = 1e-18
alter ccav1 = 1e-18
alter ccav2 = 1e-18
print @cksm[capacitance] @cks1[capacitance] @cks2[capacitance] @ccavm[capacitance] @ccav1[capacitance] @ccav2[capacitance]
tran 1e-05 19.0 0 1e-05
wrdata g3sempre_lz_iii$d v(mainjack) v(fixjack1) v(fixjack2)
wrdata g3sempre_lz_iii_stati$d v(xls.xs) v(xlp.xs) v(dep) v(ina) v(vplus) v(vminus) v(main_a) v(mainc) v(fixc1) v(fixc2)
destroy all
echo "g3sempre_lz_iii,g3sempre_lz_iii.dat,rif,1000,0,3,100k,1.0,8.5,19.0,1e-05,rif_sempre,-,-,0.0,0," >> tb_v2_casopeggiore_manifest.csv
alter vamp dc = 3.818
alter vfrq dc = 1000
alter rldm = 100k
alter rld1 = 100k
alter rld2 = 100k
alter vti dc = 1000
alter vtr dc = 2000
alter vtijk dc = 1000
alter vtrjk dc = 2000
alter vosa dc = 0
alter vosb dc = 0
alter vosf1 dc = 0
alter vosf2 dc = 0
alter ratth = 1m
alter rattb = 10k
alter rl1 = 845
alter cwire = 100p
alter vk1i dc = 1
alter vk1t dc = 1000.000000
alter vk5i dc = 1
alter vk5t dc = 1000.000000
alter vt1ri dc = 0
alter vt1rt dc = 1000.000000
alter vt1si dc = 1
alter vt1st dc = 1000.000000
alter vt2ri dc = 1
alter vt2rt dc = 1000.000000
alter vt2si dc = 0
alter vt2st dc = 1000.000000
alter vtijk dc = 1000.000000
alter vtrjk dc = 2000.000000
alter vksa dc = 1000.000000
alter vksb dc = 2000.001000
alter vkca dc = 1000.001000
alter vkcb dc = 2000.000000
alter vtiser dc = -10
alter vtrser dc = 1000
alter rbym = 1e12
alter rby1 = 1e12
alter rby2 = 1e12
alter rbcm = 220k
alter rbc1 = 470k
alter rbc2 = 470k
alter cksm = 0.1p
alter cks1 = 0.1p
alter cks2 = 0.1p
alter ccavm = 1e-18
alter ccav1 = 1e-18
alter ccav2 = 1e-18
print @cksm[capacitance] @cks1[capacitance] @cks2[capacitance] @ccavm[capacitance] @ccav1[capacitance] @ccav2[capacitance]
tran 1e-05 19.0 0 1e-05
wrdata t6mai_1k_iii$d v(mainjack) v(fixjack1) v(fixjack2)
wrdata t6mai_1k_iii_stati$d v(xls.xs) v(xlp.xs) v(dep) v(ina) v(vplus) v(vminus) v(main_a) v(mainc) v(fixc1) v(fixc2)
destroy all
echo "t6mai_1k_iii,t6mai_1k_iii.dat,rif,1000,3.818,10,100k,1.0,8.5,19.0,1e-05,rif_mai,-,-,0.0,0," >> tb_v2_casopeggiore_manifest.csv
alter vamp dc = 3.818
alter vfrq dc = 1000
alter rldm = 100k
alter rld1 = 100k
alter rld2 = 100k
alter vti dc = -10
alter vtr dc = 1000
alter vtijk dc = -10
alter vtrjk dc = 1000
alter vosa dc = 0
alter vosb dc = 0
alter vosf1 dc = 0
alter vosf2 dc = 0
alter ratth = 1m
alter rattb = 10k
alter rl1 = 845
alter cwire = 100p
alter vk1i dc = 1
alter vk1t dc = 1000.000000
alter vk5i dc = 1
alter vk5t dc = 1000.000000
alter vt1ri dc = 0
alter vt1rt dc = 1000.000000
alter vt1si dc = 1
alter vt1st dc = 1000.000000
alter vt2ri dc = 1
alter vt2rt dc = 1000.000000
alter vt2si dc = 0
alter vt2st dc = 1000.000000
alter vtijk dc = 1000.000000
alter vtrjk dc = 2000.000000
alter vksa dc = -10.000000
alter vksb dc = 1000.001000
alter vkca dc = -9.999000
alter vkcb dc = 1000.000000
alter vtiser dc = -10
alter vtrser dc = 1000
alter rbym = 1e12
alter rby1 = 1e12
alter rby2 = 1e12
alter rbcm = 220k
alter rbc1 = 470k
alter rbc2 = 470k
alter cksm = 0.1p
alter cks1 = 0.1p
alter cks2 = 0.1p
alter ccavm = 1e-18
alter ccav1 = 1e-18
alter ccav2 = 1e-18
print @cksm[capacitance] @cks1[capacitance] @cks2[capacitance] @ccavm[capacitance] @ccav1[capacitance] @ccav2[capacitance]
tran 1e-05 19.0 0 1e-05
wrdata t6sempre_1k_iii$d v(mainjack) v(fixjack1) v(fixjack2)
wrdata t6sempre_1k_iii_stati$d v(xls.xs) v(xlp.xs) v(dep) v(ina) v(vplus) v(vminus) v(main_a) v(mainc) v(fixc1) v(fixc2)
destroy all
echo "t6sempre_1k_iii,t6sempre_1k_iii.dat,rif,1000,3.818,10,100k,1.0,8.5,19.0,1e-05,rif_sempre,-,-,0.0,0," >> tb_v2_casopeggiore_manifest.csv
alter vamp dc = 3.818
alter vfrq dc = 1000
alter rldm = 100k
alter rld1 = 100k
alter rld2 = 100k
alter vti dc = 1000
alter vtr dc = 2000
alter vtijk dc = 1000
alter vtrjk dc = 2000
alter vosa dc = 0
alter vosb dc = 0
alter vosf1 dc = 0
alter vosf2 dc = 0
alter ratth = 1m
alter rattb = 10k
alter rl1 = 845
alter cwire = 100p
alter vk1i dc = 1
alter vk1t dc = 1000.000000
alter vk5i dc = 1
alter vk5t dc = 1000.000000
alter vt1ri dc = 0
alter vt1rt dc = 1000.000000
alter vt1si dc = 1
alter vt1st dc = 1000.000000
alter vt2ri dc = 0
alter vt2rt dc = 1000.000000
alter vt2si dc = 1
alter vt2st dc = 1000.000000
alter vtijk dc = 1000.000000
alter vtrjk dc = 2000.000000
alter vksa dc = 1000.000000
alter vksb dc = 2000.001000
alter vkca dc = 1000.001000
alter vkcb dc = 2000.000000
alter vtiser dc = -10
alter vtrser dc = 1000
alter rbym = 1e12
alter rby1 = 1e12
alter rby2 = 1e12
alter rbcm = 220k
alter rbc1 = 470k
alter rbc2 = 470k
alter cksm = 0.1p
alter cks1 = 0.1p
alter cks2 = 0.1p
alter ccavm = 1e-18
alter ccav1 = 1e-18
alter ccav2 = 1e-18
print @cksm[capacitance] @cks1[capacitance] @cks2[capacitance] @ccavm[capacitance] @ccav1[capacitance] @ccav2[capacitance]
tran 1e-05 19.0 0 1e-05
wrdata t12mai_1k_iii$d v(mainjack) v(fixjack1) v(fixjack2)
wrdata t12mai_1k_iii_stati$d v(xls.xs) v(xlp.xs) v(dep) v(ina) v(vplus) v(vminus) v(main_a) v(mainc) v(fixc1) v(fixc2)
destroy all
echo "t12mai_1k_iii,t12mai_1k_iii.dat,rif,1000,3.818,10,100k,1.0,8.5,19.0,1e-05,rif_mai,-,-,0.0,0," >> tb_v2_casopeggiore_manifest.csv
alter vamp dc = 3.818
alter vfrq dc = 1000
alter rldm = 100k
alter rld1 = 100k
alter rld2 = 100k
alter vti dc = -10
alter vtr dc = 1000
alter vtijk dc = -10
alter vtrjk dc = 1000
alter vosa dc = 0
alter vosb dc = 0
alter vosf1 dc = 0
alter vosf2 dc = 0
alter ratth = 1m
alter rattb = 10k
alter rl1 = 845
alter cwire = 100p
alter vk1i dc = 1
alter vk1t dc = 1000.000000
alter vk5i dc = 1
alter vk5t dc = 1000.000000
alter vt1ri dc = 0
alter vt1rt dc = 1000.000000
alter vt1si dc = 1
alter vt1st dc = 1000.000000
alter vt2ri dc = 0
alter vt2rt dc = 1000.000000
alter vt2si dc = 1
alter vt2st dc = 1000.000000
alter vtijk dc = 1000.000000
alter vtrjk dc = 2000.000000
alter vksa dc = -10.000000
alter vksb dc = 1000.001000
alter vkca dc = -9.999000
alter vkcb dc = 1000.000000
alter vtiser dc = -10
alter vtrser dc = 1000
alter rbym = 1e12
alter rby1 = 1e12
alter rby2 = 1e12
alter rbcm = 220k
alter rbc1 = 470k
alter rbc2 = 470k
alter cksm = 0.1p
alter cks1 = 0.1p
alter cks2 = 0.1p
alter ccavm = 1e-18
alter ccav1 = 1e-18
alter ccav2 = 1e-18
print @cksm[capacitance] @cks1[capacitance] @cks2[capacitance] @ccavm[capacitance] @ccav1[capacitance] @ccav2[capacitance]
tran 1e-05 19.0 0 1e-05
wrdata t12sempre_1k_iii$d v(mainjack) v(fixjack1) v(fixjack2)
wrdata t12sempre_1k_iii_stati$d v(xls.xs) v(xlp.xs) v(dep) v(ina) v(vplus) v(vminus) v(main_a) v(mainc) v(fixc1) v(fixc2)
destroy all
echo "t12sempre_1k_iii,t12sempre_1k_iii.dat,rif,1000,3.818,10,100k,1.0,8.5,19.0,1e-05,rif_sempre,-,-,0.0,0," >> tb_v2_casopeggiore_manifest.csv
alter vamp dc = 0
alter vfrq dc = 1000
alter rldm = 100k
alter rld1 = 100k
alter rld2 = 100k
alter vti dc = 1000
alter vtr dc = 2000
alter vtijk dc = 1000
alter vtrjk dc = 2000
alter vosa dc = 0
alter vosb dc = 0
alter vosf1 dc = 0
alter vosf2 dc = 0
alter ratth = 1m
alter rattb = 10k
alter rl1 = 845
alter cwire = 100p
alter vk1i dc = 1
alter vk1t dc = 1000.000000
alter vk5i dc = 1
alter vk5t dc = 1000.000000
alter vt1ri dc = 0
alter vt1rt dc = 1000.000000
alter vt1si dc = 1
alter vt1st dc = 1000.000000
alter vt2ri dc = 1
alter vt2rt dc = 1000.000000
alter vt2si dc = 0
alter vt2st dc = 1000.000000
alter vtijk dc = 1000.000000
alter vtrjk dc = 2000.000000
alter vksa dc = 1000.000000
alter vksb dc = 2000.001000
alter vkca dc = 1000.001000
alter vkcb dc = 2000.000000
alter vtiser dc = -10
alter vtrser dc = 1000
alter rbym = 1e12
alter rby1 = 1e12
alter rby2 = 1e12
alter rbcm = 220k
alter rbc1 = 470k
alter rbc2 = 470k
alter cksm = 0.1p
alter cks1 = 0.1p
alter cks2 = 0.1p
alter ccavm = 1e-18
alter ccav1 = 1e-18
alter ccav2 = 1e-18
print @cksm[capacitance] @cks1[capacitance] @cks2[capacitance] @ccavm[capacitance] @ccav1[capacitance] @ccav2[capacitance]
tran 1e-05 19.0 0 1e-05
wrdata t6mai_lz_iii$d v(mainjack) v(fixjack1) v(fixjack2)
wrdata t6mai_lz_iii_stati$d v(xls.xs) v(xlp.xs) v(dep) v(ina) v(vplus) v(vminus) v(main_a) v(mainc) v(fixc1) v(fixc2)
destroy all
echo "t6mai_lz_iii,t6mai_lz_iii.dat,rif,1000,0,10,100k,1.0,8.5,19.0,1e-05,rif_mai,-,-,0.0,0," >> tb_v2_casopeggiore_manifest.csv
alter vamp dc = 0
alter vfrq dc = 1000
alter rldm = 100k
alter rld1 = 100k
alter rld2 = 100k
alter vti dc = -10
alter vtr dc = 1000
alter vtijk dc = -10
alter vtrjk dc = 1000
alter vosa dc = 0
alter vosb dc = 0
alter vosf1 dc = 0
alter vosf2 dc = 0
alter ratth = 1m
alter rattb = 10k
alter rl1 = 845
alter cwire = 100p
alter vk1i dc = 1
alter vk1t dc = 1000.000000
alter vk5i dc = 1
alter vk5t dc = 1000.000000
alter vt1ri dc = 0
alter vt1rt dc = 1000.000000
alter vt1si dc = 1
alter vt1st dc = 1000.000000
alter vt2ri dc = 1
alter vt2rt dc = 1000.000000
alter vt2si dc = 0
alter vt2st dc = 1000.000000
alter vtijk dc = 1000.000000
alter vtrjk dc = 2000.000000
alter vksa dc = -10.000000
alter vksb dc = 1000.001000
alter vkca dc = -9.999000
alter vkcb dc = 1000.000000
alter vtiser dc = -10
alter vtrser dc = 1000
alter rbym = 1e12
alter rby1 = 1e12
alter rby2 = 1e12
alter rbcm = 220k
alter rbc1 = 470k
alter rbc2 = 470k
alter cksm = 0.1p
alter cks1 = 0.1p
alter cks2 = 0.1p
alter ccavm = 1e-18
alter ccav1 = 1e-18
alter ccav2 = 1e-18
print @cksm[capacitance] @cks1[capacitance] @cks2[capacitance] @ccavm[capacitance] @ccav1[capacitance] @ccav2[capacitance]
tran 1e-05 19.0 0 1e-05
wrdata t6sempre_lz_iii$d v(mainjack) v(fixjack1) v(fixjack2)
wrdata t6sempre_lz_iii_stati$d v(xls.xs) v(xlp.xs) v(dep) v(ina) v(vplus) v(vminus) v(main_a) v(mainc) v(fixc1) v(fixc2)
destroy all
echo "t6sempre_lz_iii,t6sempre_lz_iii.dat,rif,1000,0,10,100k,1.0,8.5,19.0,1e-05,rif_sempre,-,-,0.0,0," >> tb_v2_casopeggiore_manifest.csv
alter vamp dc = 0
alter vfrq dc = 1000
alter rldm = 100k
alter rld1 = 100k
alter rld2 = 100k
alter vti dc = 1000
alter vtr dc = 2000
alter vtijk dc = 1000
alter vtrjk dc = 2000
alter vosa dc = 0
alter vosb dc = 0
alter vosf1 dc = 0
alter vosf2 dc = 0
alter ratth = 1m
alter rattb = 10k
alter rl1 = 845
alter cwire = 100p
alter vk1i dc = 1
alter vk1t dc = 1000.000000
alter vk5i dc = 1
alter vk5t dc = 1000.000000
alter vt1ri dc = 0
alter vt1rt dc = 1000.000000
alter vt1si dc = 1
alter vt1st dc = 1000.000000
alter vt2ri dc = 0
alter vt2rt dc = 1000.000000
alter vt2si dc = 1
alter vt2st dc = 1000.000000
alter vtijk dc = 1000.000000
alter vtrjk dc = 2000.000000
alter vksa dc = 1000.000000
alter vksb dc = 2000.001000
alter vkca dc = 1000.001000
alter vkcb dc = 2000.000000
alter vtiser dc = -10
alter vtrser dc = 1000
alter rbym = 1e12
alter rby1 = 1e12
alter rby2 = 1e12
alter rbcm = 220k
alter rbc1 = 470k
alter rbc2 = 470k
alter cksm = 0.1p
alter cks1 = 0.1p
alter cks2 = 0.1p
alter ccavm = 1e-18
alter ccav1 = 1e-18
alter ccav2 = 1e-18
print @cksm[capacitance] @cks1[capacitance] @cks2[capacitance] @ccavm[capacitance] @ccav1[capacitance] @ccav2[capacitance]
tran 1e-05 19.0 0 1e-05
wrdata t12mai_lz_iii$d v(mainjack) v(fixjack1) v(fixjack2)
wrdata t12mai_lz_iii_stati$d v(xls.xs) v(xlp.xs) v(dep) v(ina) v(vplus) v(vminus) v(main_a) v(mainc) v(fixc1) v(fixc2)
destroy all
echo "t12mai_lz_iii,t12mai_lz_iii.dat,rif,1000,0,10,100k,1.0,8.5,19.0,1e-05,rif_mai,-,-,0.0,0," >> tb_v2_casopeggiore_manifest.csv
alter vamp dc = 0
alter vfrq dc = 1000
alter rldm = 100k
alter rld1 = 100k
alter rld2 = 100k
alter vti dc = -10
alter vtr dc = 1000
alter vtijk dc = -10
alter vtrjk dc = 1000
alter vosa dc = 0
alter vosb dc = 0
alter vosf1 dc = 0
alter vosf2 dc = 0
alter ratth = 1m
alter rattb = 10k
alter rl1 = 845
alter cwire = 100p
alter vk1i dc = 1
alter vk1t dc = 1000.000000
alter vk5i dc = 1
alter vk5t dc = 1000.000000
alter vt1ri dc = 0
alter vt1rt dc = 1000.000000
alter vt1si dc = 1
alter vt1st dc = 1000.000000
alter vt2ri dc = 0
alter vt2rt dc = 1000.000000
alter vt2si dc = 1
alter vt2st dc = 1000.000000
alter vtijk dc = 1000.000000
alter vtrjk dc = 2000.000000
alter vksa dc = -10.000000
alter vksb dc = 1000.001000
alter vkca dc = -9.999000
alter vkcb dc = 1000.000000
alter vtiser dc = -10
alter vtrser dc = 1000
alter rbym = 1e12
alter rby1 = 1e12
alter rby2 = 1e12
alter rbcm = 220k
alter rbc1 = 470k
alter rbc2 = 470k
alter cksm = 0.1p
alter cks1 = 0.1p
alter cks2 = 0.1p
alter ccavm = 1e-18
alter ccav1 = 1e-18
alter ccav2 = 1e-18
print @cksm[capacitance] @cks1[capacitance] @cks2[capacitance] @ccavm[capacitance] @ccav1[capacitance] @ccav2[capacitance]
tran 1e-05 19.0 0 1e-05
wrdata t12sempre_lz_iii$d v(mainjack) v(fixjack1) v(fixjack2)
wrdata t12sempre_lz_iii_stati$d v(xls.xs) v(xlp.xs) v(dep) v(ina) v(vplus) v(vminus) v(main_a) v(mainc) v(fixc1) v(fixc2)
destroy all
echo "t12sempre_lz_iii,t12sempre_lz_iii.dat,rif,1000,0,10,100k,1.0,8.5,19.0,1e-05,rif_sempre,-,-,0.0,0," >> tb_v2_casopeggiore_manifest.csv
* ---- L29d2 1: gm0x3_1k_iii ----
alter vamp dc = 3.818
alter vfrq dc = 1000
alter rldm = 100k
alter rld1 = 100k
alter rld2 = 100k
alter vti dc = 1.0
alter vtr dc = 10.0
alter vtijk dc = 7.5
alter vtrjk dc = 10.0
alter vosa dc = 0
alter vosb dc = 0
alter vosf1 dc = 0
alter vosf2 dc = 0
alter ratth = 1m
alter rattb = 10k
alter rl1 = 845
alter cwire = 100p
alter vk1i dc = 0
alter vk1t dc = 8.000000
alter vk5i dc = 0
alter vk5t dc = 1000.000000
alter vt1ri dc = 1
alter vt1rt dc = 1000.000000
alter vt1si dc = 0
alter vt1st dc = 1000.000000
alter vt2ri dc = 1
alter vt2rt dc = 1000.000000
alter vt2si dc = 0
alter vt2st dc = 1000.000000
alter vtijk dc = 1000.000000
alter vtrjk dc = 2000.000000
alter vksa dc = 7.500000
alter vksb dc = 10.001000
alter vkca dc = 7.501000
alter vkcb dc = 10.000000
alter vtiser dc = -10
alter vtrser dc = 1000
alter rbym = 1e12
alter rby1 = 1e12
alter rby2 = 1e12
alter rbcm = 220k
alter rbc1 = 470k
alter rbc2 = 470k
alter cksm = 0.1p
alter cks1 = 0.1p
alter cks2 = 0.1p
alter ccavm = 1e-18
alter ccav1 = 1e-18
alter ccav2 = 1e-18
print @cksm[capacitance] @cks1[capacitance] @cks2[capacitance] @ccavm[capacitance] @ccav1[capacitance] @ccav2[capacitance]
tran 1e-05 19.0 0 1e-05
wrdata gm0x3_1k_iii$d v(mainjack) v(fixjack1) v(fixjack2)
wrdata gm0x3_1k_iii_stati$d v(xls.xs) v(xlp.xs) v(dep) v(ina) v(vplus) v(vminus) v(main_a) v(mainc) v(fixc1) v(fixc2)
destroy all
echo "gm0x3_1k_iii_i,gm0x3_1k_iii.dat,l29d2_iii,1000,3.818,0a3,100k,1.0,8.0,19.0,1e-05,evento,g0sempre_1k_iii,g0mai_1k_iii,6.5,1,S_ins;B2" >> tb_v2_casopeggiore_manifest.csv
echo "gm0x3_1k_iii_c,gm0x3_1k_iii.dat,l29d2_iii,1000,3.818,0a3,100k,8.0,10.0,19.0,1e-05,evento,g3sempre_1k_iii,g3mai_1k_iii,0.0,1,S_rel;B2" >> tb_v2_casopeggiore_manifest.csv
* ---- L29d2 1: gm3x0_1k_iii ----
alter vamp dc = 3.818
alter vfrq dc = 1000
alter rldm = 100k
alter rld1 = 100k
alter rld2 = 100k
alter vti dc = 1.0
alter vtr dc = 10.0
alter vtijk dc = 7.5
alter vtrjk dc = 10.0
alter vosa dc = 0
alter vosb dc = 0
alter vosf1 dc = 0
alter vosf2 dc = 0
alter ratth = 1m
alter rattb = 10k
alter rl1 = 845
alter cwire = 100p
alter vk1i dc = 1
alter vk1t dc = 8.000000
alter vk5i dc = 0
alter vk5t dc = 1000.000000
alter vt1ri dc = 1
alter vt1rt dc = 1000.000000
alter vt1si dc = 0
alter vt1st dc = 1000.000000
alter vt2ri dc = 1
alter vt2rt dc = 1000.000000
alter vt2si dc = 0
alter vt2st dc = 1000.000000
alter vtijk dc = 1000.000000
alter vtrjk dc = 2000.000000
alter vksa dc = 7.500000
alter vksb dc = 10.001000
alter vkca dc = 7.501000
alter vkcb dc = 10.000000
alter vtiser dc = -10
alter vtrser dc = 1000
alter rbym = 1e12
alter rby1 = 1e12
alter rby2 = 1e12
alter rbcm = 220k
alter rbc1 = 470k
alter rbc2 = 470k
alter cksm = 0.1p
alter cks1 = 0.1p
alter cks2 = 0.1p
alter ccavm = 1e-18
alter ccav1 = 1e-18
alter ccav2 = 1e-18
print @cksm[capacitance] @cks1[capacitance] @cks2[capacitance] @ccavm[capacitance] @ccav1[capacitance] @ccav2[capacitance]
tran 1e-05 19.0 0 1e-05
wrdata gm3x0_1k_iii$d v(mainjack) v(fixjack1) v(fixjack2)
wrdata gm3x0_1k_iii_stati$d v(xls.xs) v(xlp.xs) v(dep) v(ina) v(vplus) v(vminus) v(main_a) v(mainc) v(fixc1) v(fixc2)
destroy all
echo "gm3x0_1k_iii_i,gm3x0_1k_iii.dat,l29d2_iii,1000,3.818,3a0,100k,1.0,8.0,19.0,1e-05,evento,g3sempre_1k_iii,g3mai_1k_iii,6.5,1,S_ins;B2" >> tb_v2_casopeggiore_manifest.csv
echo "gm3x0_1k_iii_c,gm3x0_1k_iii.dat,l29d2_iii,1000,3.818,3a0,100k,8.0,10.0,19.0,1e-05,evento,g0sempre_1k_iii,g0mai_1k_iii,0.0,1,S_rel;B2" >> tb_v2_casopeggiore_manifest.csv
* ---- L29d2 1: gm3x10_1k_iii ----
alter vamp dc = 3.818
alter vfrq dc = 1000
alter rldm = 100k
alter rld1 = 100k
alter rld2 = 100k
alter vti dc = 1.0
alter vtr dc = 10.0
alter vtijk dc = 7.5
alter vtrjk dc = 10.0
alter vosa dc = 0
alter vosb dc = 0
alter vosf1 dc = 0
alter vosf2 dc = 0
alter ratth = 1m
alter rattb = 10k
alter rl1 = 845
alter cwire = 100p
alter vk1i dc = 1
alter vk1t dc = 1000.000000
alter vk5i dc = 0
alter vk5t dc = 8.000000
alter vt1ri dc = 1
alter vt1rt dc = 1000.000000
alter vt1si dc = 0
alter vt1st dc = 1000.000000
alter vt2ri dc = 1
alter vt2rt dc = 1000.000000
alter vt2si dc = 0
alter vt2st dc = 1000.000000
alter vtijk dc = 1000.000000
alter vtrjk dc = 2000.000000
alter vksa dc = 7.500000
alter vksb dc = 10.001000
alter vkca dc = 7.501000
alter vkcb dc = 10.000000
alter vtiser dc = -10
alter vtrser dc = 1000
alter rbym = 1e12
alter rby1 = 1e12
alter rby2 = 1e12
alter rbcm = 220k
alter rbc1 = 470k
alter rbc2 = 470k
alter cksm = 0.1p
alter cks1 = 0.1p
alter cks2 = 0.1p
alter ccavm = 1e-18
alter ccav1 = 1e-18
alter ccav2 = 1e-18
print @cksm[capacitance] @cks1[capacitance] @cks2[capacitance] @ccavm[capacitance] @ccav1[capacitance] @ccav2[capacitance]
tran 1e-05 19.0 0 1e-05
wrdata gm3x10_1k_iii$d v(mainjack) v(fixjack1) v(fixjack2)
wrdata gm3x10_1k_iii_stati$d v(xls.xs) v(xlp.xs) v(dep) v(ina) v(vplus) v(vminus) v(main_a) v(mainc) v(fixc1) v(fixc2)
destroy all
echo "gm3x10_1k_iii_i,gm3x10_1k_iii.dat,l29d2_iii,1000,3.818,3a10,100k,1.0,8.0,19.0,1e-05,evento,g3sempre_1k_iii,g3mai_1k_iii,6.5,1,S_ins;B2" >> tb_v2_casopeggiore_manifest.csv
echo "gm3x10_1k_iii_c,gm3x10_1k_iii.dat,l29d2_iii,1000,3.818,3a10,100k,8.0,10.0,19.0,1e-05,evento,g10sempre_1k_iii,g10mai_1k_iii,0.0,1,S_rel;B2" >> tb_v2_casopeggiore_manifest.csv
* ---- L29d2 1: gm10x3_1k_iii ----
alter vamp dc = 3.818
alter vfrq dc = 1000
alter rldm = 100k
alter rld1 = 100k
alter rld2 = 100k
alter vti dc = 1.0
alter vtr dc = 10.0
alter vtijk dc = 7.5
alter vtrjk dc = 10.0
alter vosa dc = 0
alter vosb dc = 0
alter vosf1 dc = 0
alter vosf2 dc = 0
alter ratth = 1m
alter rattb = 10k
alter rl1 = 845
alter cwire = 100p
alter vk1i dc = 1
alter vk1t dc = 1000.000000
alter vk5i dc = 1
alter vk5t dc = 8.000000
alter vt1ri dc = 1
alter vt1rt dc = 1000.000000
alter vt1si dc = 0
alter vt1st dc = 1000.000000
alter vt2ri dc = 1
alter vt2rt dc = 1000.000000
alter vt2si dc = 0
alter vt2st dc = 1000.000000
alter vtijk dc = 1000.000000
alter vtrjk dc = 2000.000000
alter vksa dc = 7.500000
alter vksb dc = 10.001000
alter vkca dc = 7.501000
alter vkcb dc = 10.000000
alter vtiser dc = -10
alter vtrser dc = 1000
alter rbym = 1e12
alter rby1 = 1e12
alter rby2 = 1e12
alter rbcm = 220k
alter rbc1 = 470k
alter rbc2 = 470k
alter cksm = 0.1p
alter cks1 = 0.1p
alter cks2 = 0.1p
alter ccavm = 1e-18
alter ccav1 = 1e-18
alter ccav2 = 1e-18
print @cksm[capacitance] @cks1[capacitance] @cks2[capacitance] @ccavm[capacitance] @ccav1[capacitance] @ccav2[capacitance]
tran 1e-05 19.0 0 1e-05
wrdata gm10x3_1k_iii$d v(mainjack) v(fixjack1) v(fixjack2)
wrdata gm10x3_1k_iii_stati$d v(xls.xs) v(xlp.xs) v(dep) v(ina) v(vplus) v(vminus) v(main_a) v(mainc) v(fixc1) v(fixc2)
destroy all
echo "gm10x3_1k_iii_i,gm10x3_1k_iii.dat,l29d2_iii,1000,3.818,10a3,100k,1.0,8.0,19.0,1e-05,evento,g10sempre_1k_iii,g10mai_1k_iii,6.5,1,S_ins;B2" >> tb_v2_casopeggiore_manifest.csv
echo "gm10x3_1k_iii_c,gm10x3_1k_iii.dat,l29d2_iii,1000,3.818,10a3,100k,8.0,10.0,19.0,1e-05,evento,g3sempre_1k_iii,g3mai_1k_iii,0.0,1,S_rel;B2" >> tb_v2_casopeggiore_manifest.csv
* ---- L29d2 1: gm0x10_1k_iii ----
alter vamp dc = 3.818
alter vfrq dc = 1000
alter rldm = 100k
alter rld1 = 100k
alter rld2 = 100k
alter vti dc = 1.0
alter vtr dc = 10.0
alter vtijk dc = 7.5
alter vtrjk dc = 10.0
alter vosa dc = 0
alter vosb dc = 0
alter vosf1 dc = 0
alter vosf2 dc = 0
alter ratth = 1m
alter rattb = 10k
alter rl1 = 845
alter cwire = 100p
alter vk1i dc = 0
alter vk1t dc = 8.000300
alter vk5i dc = 0
alter vk5t dc = 8.000000
alter vt1ri dc = 1
alter vt1rt dc = 1000.000000
alter vt1si dc = 0
alter vt1st dc = 1000.000000
alter vt2ri dc = 1
alter vt2rt dc = 1000.000000
alter vt2si dc = 0
alter vt2st dc = 1000.000000
alter vtijk dc = 1000.000000
alter vtrjk dc = 2000.000000
alter vksa dc = 7.500000
alter vksb dc = 10.001000
alter vkca dc = 7.501000
alter vkcb dc = 10.000000
alter vtiser dc = -10
alter vtrser dc = 1000
alter rbym = 1e12
alter rby1 = 1e12
alter rby2 = 1e12
alter rbcm = 220k
alter rbc1 = 470k
alter rbc2 = 470k
alter cksm = 0.1p
alter cks1 = 0.1p
alter cks2 = 0.1p
alter ccavm = 1e-18
alter ccav1 = 1e-18
alter ccav2 = 1e-18
print @cksm[capacitance] @cks1[capacitance] @cks2[capacitance] @ccavm[capacitance] @ccav1[capacitance] @ccav2[capacitance]
tran 1e-05 19.0 0 1e-05
wrdata gm0x10_1k_iii$d v(mainjack) v(fixjack1) v(fixjack2)
wrdata gm0x10_1k_iii_stati$d v(xls.xs) v(xlp.xs) v(dep) v(ina) v(vplus) v(vminus) v(main_a) v(mainc) v(fixc1) v(fixc2)
destroy all
echo "gm0x10_1k_iii_i,gm0x10_1k_iii.dat,l29d2_iii,1000,3.818,0a10,100k,1.0,8.0,19.0,1e-05,evento,g0sempre_1k_iii,g0mai_1k_iii,6.5,1,S_ins;B2" >> tb_v2_casopeggiore_manifest.csv
echo "gm0x10_1k_iii_c,gm0x10_1k_iii.dat,l29d2_iii,1000,3.818,0a10,100k,8.0,10.0,19.0,1e-05,evento,g10sempre_1k_iii,g10mai_1k_iii,0.0,1,S_rel;B2" >> tb_v2_casopeggiore_manifest.csv
* ---- L29d2 1: gm10x0_1k_iii ----
alter vamp dc = 3.818
alter vfrq dc = 1000
alter rldm = 100k
alter rld1 = 100k
alter rld2 = 100k
alter vti dc = 1.0
alter vtr dc = 10.0
alter vtijk dc = 7.5
alter vtrjk dc = 10.0
alter vosa dc = 0
alter vosb dc = 0
alter vosf1 dc = 0
alter vosf2 dc = 0
alter ratth = 1m
alter rattb = 10k
alter rl1 = 845
alter cwire = 100p
alter vk1i dc = 1
alter vk1t dc = 8.000000
alter vk5i dc = 1
alter vk5t dc = 8.000300
alter vt1ri dc = 1
alter vt1rt dc = 1000.000000
alter vt1si dc = 0
alter vt1st dc = 1000.000000
alter vt2ri dc = 1
alter vt2rt dc = 1000.000000
alter vt2si dc = 0
alter vt2st dc = 1000.000000
alter vtijk dc = 1000.000000
alter vtrjk dc = 2000.000000
alter vksa dc = 7.500000
alter vksb dc = 10.001000
alter vkca dc = 7.501000
alter vkcb dc = 10.000000
alter vtiser dc = -10
alter vtrser dc = 1000
alter rbym = 1e12
alter rby1 = 1e12
alter rby2 = 1e12
alter rbcm = 220k
alter rbc1 = 470k
alter rbc2 = 470k
alter cksm = 0.1p
alter cks1 = 0.1p
alter cks2 = 0.1p
alter ccavm = 1e-18
alter ccav1 = 1e-18
alter ccav2 = 1e-18
print @cksm[capacitance] @cks1[capacitance] @cks2[capacitance] @ccavm[capacitance] @ccav1[capacitance] @ccav2[capacitance]
tran 1e-05 19.0 0 1e-05
wrdata gm10x0_1k_iii$d v(mainjack) v(fixjack1) v(fixjack2)
wrdata gm10x0_1k_iii_stati$d v(xls.xs) v(xlp.xs) v(dep) v(ina) v(vplus) v(vminus) v(main_a) v(mainc) v(fixc1) v(fixc2)
destroy all
echo "gm10x0_1k_iii_i,gm10x0_1k_iii.dat,l29d2_iii,1000,3.818,10a0,100k,1.0,8.0,19.0,1e-05,evento,g10sempre_1k_iii,g10mai_1k_iii,6.5,1,S_ins;B2" >> tb_v2_casopeggiore_manifest.csv
echo "gm10x0_1k_iii_c,gm10x0_1k_iii.dat,l29d2_iii,1000,3.818,10a0,100k,8.0,10.0,19.0,1e-05,evento,g0sempre_1k_iii,g0mai_1k_iii,0.0,1,S_rel;B2" >> tb_v2_casopeggiore_manifest.csv
* ---- L29d2 1: gm0x3_20_iii ----
alter vamp dc = 3.818
alter vfrq dc = 20
alter rldm = 100k
alter rld1 = 100k
alter rld2 = 100k
alter vti dc = 1.0
alter vtr dc = 10.0
alter vtijk dc = 7.5
alter vtrjk dc = 10.0
alter vosa dc = 0
alter vosb dc = 0
alter vosf1 dc = 0
alter vosf2 dc = 0
alter ratth = 1m
alter rattb = 10k
alter rl1 = 845
alter cwire = 100p
alter vk1i dc = 0
alter vk1t dc = 8.000000
alter vk5i dc = 0
alter vk5t dc = 1000.000000
alter vt1ri dc = 1
alter vt1rt dc = 1000.000000
alter vt1si dc = 0
alter vt1st dc = 1000.000000
alter vt2ri dc = 1
alter vt2rt dc = 1000.000000
alter vt2si dc = 0
alter vt2st dc = 1000.000000
alter vtijk dc = 1000.000000
alter vtrjk dc = 2000.000000
alter vksa dc = 7.500000
alter vksb dc = 10.001000
alter vkca dc = 7.501000
alter vkcb dc = 10.000000
alter vtiser dc = -10
alter vtrser dc = 1000
alter rbym = 1e12
alter rby1 = 1e12
alter rby2 = 1e12
alter rbcm = 220k
alter rbc1 = 470k
alter rbc2 = 470k
alter cksm = 0.1p
alter cks1 = 0.1p
alter cks2 = 0.1p
alter ccavm = 1e-18
alter ccav1 = 1e-18
alter ccav2 = 1e-18
print @cksm[capacitance] @cks1[capacitance] @cks2[capacitance] @ccavm[capacitance] @ccav1[capacitance] @ccav2[capacitance]
tran 1e-05 19.0 0 1e-05
wrdata gm0x3_20_iii$d v(mainjack) v(fixjack1) v(fixjack2)
wrdata gm0x3_20_iii_stati$d v(xls.xs) v(xlp.xs) v(dep) v(ina) v(vplus) v(vminus) v(main_a) v(mainc) v(fixc1) v(fixc2)
destroy all
echo "gm0x3_20_iii_i,gm0x3_20_iii.dat,l29d2_iii,20,3.818,0a3,100k,1.0,8.0,19.0,1e-05,evento,g0sempre_20_iii,g0mai_20_iii,6.5,1,S_ins;B2" >> tb_v2_casopeggiore_manifest.csv
echo "gm0x3_20_iii_c,gm0x3_20_iii.dat,l29d2_iii,20,3.818,0a3,100k,8.0,10.0,19.0,1e-05,evento,g3sempre_20_iii,g3mai_20_iii,0.0,1,S_rel;B2" >> tb_v2_casopeggiore_manifest.csv
* ---- L29d2 1: gm3x0_20_iii ----
alter vamp dc = 3.818
alter vfrq dc = 20
alter rldm = 100k
alter rld1 = 100k
alter rld2 = 100k
alter vti dc = 1.0
alter vtr dc = 10.0
alter vtijk dc = 7.5
alter vtrjk dc = 10.0
alter vosa dc = 0
alter vosb dc = 0
alter vosf1 dc = 0
alter vosf2 dc = 0
alter ratth = 1m
alter rattb = 10k
alter rl1 = 845
alter cwire = 100p
alter vk1i dc = 1
alter vk1t dc = 8.000000
alter vk5i dc = 0
alter vk5t dc = 1000.000000
alter vt1ri dc = 1
alter vt1rt dc = 1000.000000
alter vt1si dc = 0
alter vt1st dc = 1000.000000
alter vt2ri dc = 1
alter vt2rt dc = 1000.000000
alter vt2si dc = 0
alter vt2st dc = 1000.000000
alter vtijk dc = 1000.000000
alter vtrjk dc = 2000.000000
alter vksa dc = 7.500000
alter vksb dc = 10.001000
alter vkca dc = 7.501000
alter vkcb dc = 10.000000
alter vtiser dc = -10
alter vtrser dc = 1000
alter rbym = 1e12
alter rby1 = 1e12
alter rby2 = 1e12
alter rbcm = 220k
alter rbc1 = 470k
alter rbc2 = 470k
alter cksm = 0.1p
alter cks1 = 0.1p
alter cks2 = 0.1p
alter ccavm = 1e-18
alter ccav1 = 1e-18
alter ccav2 = 1e-18
print @cksm[capacitance] @cks1[capacitance] @cks2[capacitance] @ccavm[capacitance] @ccav1[capacitance] @ccav2[capacitance]
tran 1e-05 19.0 0 1e-05
wrdata gm3x0_20_iii$d v(mainjack) v(fixjack1) v(fixjack2)
wrdata gm3x0_20_iii_stati$d v(xls.xs) v(xlp.xs) v(dep) v(ina) v(vplus) v(vminus) v(main_a) v(mainc) v(fixc1) v(fixc2)
destroy all
echo "gm3x0_20_iii_i,gm3x0_20_iii.dat,l29d2_iii,20,3.818,3a0,100k,1.0,8.0,19.0,1e-05,evento,g3sempre_20_iii,g3mai_20_iii,6.5,1,S_ins;B2" >> tb_v2_casopeggiore_manifest.csv
echo "gm3x0_20_iii_c,gm3x0_20_iii.dat,l29d2_iii,20,3.818,3a0,100k,8.0,10.0,19.0,1e-05,evento,g0sempre_20_iii,g0mai_20_iii,0.0,1,S_rel;B2" >> tb_v2_casopeggiore_manifest.csv
* ---- L29d2 1: gm3x10_20_iii ----
alter vamp dc = 3.818
alter vfrq dc = 20
alter rldm = 100k
alter rld1 = 100k
alter rld2 = 100k
alter vti dc = 1.0
alter vtr dc = 10.0
alter vtijk dc = 7.5
alter vtrjk dc = 10.0
alter vosa dc = 0
alter vosb dc = 0
alter vosf1 dc = 0
alter vosf2 dc = 0
alter ratth = 1m
alter rattb = 10k
alter rl1 = 845
alter cwire = 100p
alter vk1i dc = 1
alter vk1t dc = 1000.000000
alter vk5i dc = 0
alter vk5t dc = 8.000000
alter vt1ri dc = 1
alter vt1rt dc = 1000.000000
alter vt1si dc = 0
alter vt1st dc = 1000.000000
alter vt2ri dc = 1
alter vt2rt dc = 1000.000000
alter vt2si dc = 0
alter vt2st dc = 1000.000000
alter vtijk dc = 1000.000000
alter vtrjk dc = 2000.000000
alter vksa dc = 7.500000
alter vksb dc = 10.001000
alter vkca dc = 7.501000
alter vkcb dc = 10.000000
alter vtiser dc = -10
alter vtrser dc = 1000
alter rbym = 1e12
alter rby1 = 1e12
alter rby2 = 1e12
alter rbcm = 220k
alter rbc1 = 470k
alter rbc2 = 470k
alter cksm = 0.1p
alter cks1 = 0.1p
alter cks2 = 0.1p
alter ccavm = 1e-18
alter ccav1 = 1e-18
alter ccav2 = 1e-18
print @cksm[capacitance] @cks1[capacitance] @cks2[capacitance] @ccavm[capacitance] @ccav1[capacitance] @ccav2[capacitance]
tran 1e-05 19.0 0 1e-05
wrdata gm3x10_20_iii$d v(mainjack) v(fixjack1) v(fixjack2)
wrdata gm3x10_20_iii_stati$d v(xls.xs) v(xlp.xs) v(dep) v(ina) v(vplus) v(vminus) v(main_a) v(mainc) v(fixc1) v(fixc2)
destroy all
echo "gm3x10_20_iii_i,gm3x10_20_iii.dat,l29d2_iii,20,3.818,3a10,100k,1.0,8.0,19.0,1e-05,evento,g3sempre_20_iii,g3mai_20_iii,6.5,1,S_ins;B2" >> tb_v2_casopeggiore_manifest.csv
echo "gm3x10_20_iii_c,gm3x10_20_iii.dat,l29d2_iii,20,3.818,3a10,100k,8.0,10.0,19.0,1e-05,evento,g10sempre_20_iii,g10mai_20_iii,0.0,1,S_rel;B2" >> tb_v2_casopeggiore_manifest.csv
* ---- L29d2 1: gm10x3_20_iii ----
alter vamp dc = 3.818
alter vfrq dc = 20
alter rldm = 100k
alter rld1 = 100k
alter rld2 = 100k
alter vti dc = 1.0
alter vtr dc = 10.0
alter vtijk dc = 7.5
alter vtrjk dc = 10.0
alter vosa dc = 0
alter vosb dc = 0
alter vosf1 dc = 0
alter vosf2 dc = 0
alter ratth = 1m
alter rattb = 10k
alter rl1 = 845
alter cwire = 100p
alter vk1i dc = 1
alter vk1t dc = 1000.000000
alter vk5i dc = 1
alter vk5t dc = 8.000000
alter vt1ri dc = 1
alter vt1rt dc = 1000.000000
alter vt1si dc = 0
alter vt1st dc = 1000.000000
alter vt2ri dc = 1
alter vt2rt dc = 1000.000000
alter vt2si dc = 0
alter vt2st dc = 1000.000000
alter vtijk dc = 1000.000000
alter vtrjk dc = 2000.000000
alter vksa dc = 7.500000
alter vksb dc = 10.001000
alter vkca dc = 7.501000
alter vkcb dc = 10.000000
alter vtiser dc = -10
alter vtrser dc = 1000
alter rbym = 1e12
alter rby1 = 1e12
alter rby2 = 1e12
alter rbcm = 220k
alter rbc1 = 470k
alter rbc2 = 470k
alter cksm = 0.1p
alter cks1 = 0.1p
alter cks2 = 0.1p
alter ccavm = 1e-18
alter ccav1 = 1e-18
alter ccav2 = 1e-18
print @cksm[capacitance] @cks1[capacitance] @cks2[capacitance] @ccavm[capacitance] @ccav1[capacitance] @ccav2[capacitance]
tran 1e-05 19.0 0 1e-05
wrdata gm10x3_20_iii$d v(mainjack) v(fixjack1) v(fixjack2)
wrdata gm10x3_20_iii_stati$d v(xls.xs) v(xlp.xs) v(dep) v(ina) v(vplus) v(vminus) v(main_a) v(mainc) v(fixc1) v(fixc2)
destroy all
echo "gm10x3_20_iii_i,gm10x3_20_iii.dat,l29d2_iii,20,3.818,10a3,100k,1.0,8.0,19.0,1e-05,evento,g10sempre_20_iii,g10mai_20_iii,6.5,1,S_ins;B2" >> tb_v2_casopeggiore_manifest.csv
echo "gm10x3_20_iii_c,gm10x3_20_iii.dat,l29d2_iii,20,3.818,10a3,100k,8.0,10.0,19.0,1e-05,evento,g3sempre_20_iii,g3mai_20_iii,0.0,1,S_rel;B2" >> tb_v2_casopeggiore_manifest.csv
* ---- L29d2 1: gm0x10_20_iii ----
alter vamp dc = 3.818
alter vfrq dc = 20
alter rldm = 100k
alter rld1 = 100k
alter rld2 = 100k
alter vti dc = 1.0
alter vtr dc = 10.0
alter vtijk dc = 7.5
alter vtrjk dc = 10.0
alter vosa dc = 0
alter vosb dc = 0
alter vosf1 dc = 0
alter vosf2 dc = 0
alter ratth = 1m
alter rattb = 10k
alter rl1 = 845
alter cwire = 100p
alter vk1i dc = 0
alter vk1t dc = 8.000300
alter vk5i dc = 0
alter vk5t dc = 8.000000
alter vt1ri dc = 1
alter vt1rt dc = 1000.000000
alter vt1si dc = 0
alter vt1st dc = 1000.000000
alter vt2ri dc = 1
alter vt2rt dc = 1000.000000
alter vt2si dc = 0
alter vt2st dc = 1000.000000
alter vtijk dc = 1000.000000
alter vtrjk dc = 2000.000000
alter vksa dc = 7.500000
alter vksb dc = 10.001000
alter vkca dc = 7.501000
alter vkcb dc = 10.000000
alter vtiser dc = -10
alter vtrser dc = 1000
alter rbym = 1e12
alter rby1 = 1e12
alter rby2 = 1e12
alter rbcm = 220k
alter rbc1 = 470k
alter rbc2 = 470k
alter cksm = 0.1p
alter cks1 = 0.1p
alter cks2 = 0.1p
alter ccavm = 1e-18
alter ccav1 = 1e-18
alter ccav2 = 1e-18
print @cksm[capacitance] @cks1[capacitance] @cks2[capacitance] @ccavm[capacitance] @ccav1[capacitance] @ccav2[capacitance]
tran 1e-05 19.0 0 1e-05
wrdata gm0x10_20_iii$d v(mainjack) v(fixjack1) v(fixjack2)
wrdata gm0x10_20_iii_stati$d v(xls.xs) v(xlp.xs) v(dep) v(ina) v(vplus) v(vminus) v(main_a) v(mainc) v(fixc1) v(fixc2)
destroy all
echo "gm0x10_20_iii_i,gm0x10_20_iii.dat,l29d2_iii,20,3.818,0a10,100k,1.0,8.0,19.0,1e-05,evento,g0sempre_20_iii,g0mai_20_iii,6.5,1,S_ins;B2" >> tb_v2_casopeggiore_manifest.csv
echo "gm0x10_20_iii_c,gm0x10_20_iii.dat,l29d2_iii,20,3.818,0a10,100k,8.0,10.0,19.0,1e-05,evento,g10sempre_20_iii,g10mai_20_iii,0.0,1,S_rel;B2" >> tb_v2_casopeggiore_manifest.csv
* ---- L29d2 1: gm10x0_20_iii ----
alter vamp dc = 3.818
alter vfrq dc = 20
alter rldm = 100k
alter rld1 = 100k
alter rld2 = 100k
alter vti dc = 1.0
alter vtr dc = 10.0
alter vtijk dc = 7.5
alter vtrjk dc = 10.0
alter vosa dc = 0
alter vosb dc = 0
alter vosf1 dc = 0
alter vosf2 dc = 0
alter ratth = 1m
alter rattb = 10k
alter rl1 = 845
alter cwire = 100p
alter vk1i dc = 1
alter vk1t dc = 8.000000
alter vk5i dc = 1
alter vk5t dc = 8.000300
alter vt1ri dc = 1
alter vt1rt dc = 1000.000000
alter vt1si dc = 0
alter vt1st dc = 1000.000000
alter vt2ri dc = 1
alter vt2rt dc = 1000.000000
alter vt2si dc = 0
alter vt2st dc = 1000.000000
alter vtijk dc = 1000.000000
alter vtrjk dc = 2000.000000
alter vksa dc = 7.500000
alter vksb dc = 10.001000
alter vkca dc = 7.501000
alter vkcb dc = 10.000000
alter vtiser dc = -10
alter vtrser dc = 1000
alter rbym = 1e12
alter rby1 = 1e12
alter rby2 = 1e12
alter rbcm = 220k
alter rbc1 = 470k
alter rbc2 = 470k
alter cksm = 0.1p
alter cks1 = 0.1p
alter cks2 = 0.1p
alter ccavm = 1e-18
alter ccav1 = 1e-18
alter ccav2 = 1e-18
print @cksm[capacitance] @cks1[capacitance] @cks2[capacitance] @ccavm[capacitance] @ccav1[capacitance] @ccav2[capacitance]
tran 1e-05 19.0 0 1e-05
wrdata gm10x0_20_iii$d v(mainjack) v(fixjack1) v(fixjack2)
wrdata gm10x0_20_iii_stati$d v(xls.xs) v(xlp.xs) v(dep) v(ina) v(vplus) v(vminus) v(main_a) v(mainc) v(fixc1) v(fixc2)
destroy all
echo "gm10x0_20_iii_i,gm10x0_20_iii.dat,l29d2_iii,20,3.818,10a0,100k,1.0,8.0,19.0,1e-05,evento,g10sempre_20_iii,g10mai_20_iii,6.5,1,S_ins;B2" >> tb_v2_casopeggiore_manifest.csv
echo "gm10x0_20_iii_c,gm10x0_20_iii.dat,l29d2_iii,20,3.818,10a0,100k,8.0,10.0,19.0,1e-05,evento,g0sempre_20_iii,g0mai_20_iii,0.0,1,S_rel;B2" >> tb_v2_casopeggiore_manifest.csv
* ---- L29d2 1: gm0x3_lz_iii ----
alter vamp dc = 0
alter vfrq dc = 1000
alter rldm = 100k
alter rld1 = 100k
alter rld2 = 100k
alter vti dc = 1.0
alter vtr dc = 10.0
alter vtijk dc = 7.5
alter vtrjk dc = 10.0
alter vosa dc = 0
alter vosb dc = 0
alter vosf1 dc = 0
alter vosf2 dc = 0
alter ratth = 1m
alter rattb = 10k
alter rl1 = 845
alter cwire = 100p
alter vk1i dc = 0
alter vk1t dc = 8.000000
alter vk5i dc = 0
alter vk5t dc = 1000.000000
alter vt1ri dc = 1
alter vt1rt dc = 1000.000000
alter vt1si dc = 0
alter vt1st dc = 1000.000000
alter vt2ri dc = 1
alter vt2rt dc = 1000.000000
alter vt2si dc = 0
alter vt2st dc = 1000.000000
alter vtijk dc = 1000.000000
alter vtrjk dc = 2000.000000
alter vksa dc = 7.500000
alter vksb dc = 10.001000
alter vkca dc = 7.501000
alter vkcb dc = 10.000000
alter vtiser dc = -10
alter vtrser dc = 1000
alter rbym = 1e12
alter rby1 = 1e12
alter rby2 = 1e12
alter rbcm = 220k
alter rbc1 = 470k
alter rbc2 = 470k
alter cksm = 0.1p
alter cks1 = 0.1p
alter cks2 = 0.1p
alter ccavm = 1e-18
alter ccav1 = 1e-18
alter ccav2 = 1e-18
print @cksm[capacitance] @cks1[capacitance] @cks2[capacitance] @ccavm[capacitance] @ccav1[capacitance] @ccav2[capacitance]
tran 1e-05 19.0 0 1e-05
wrdata gm0x3_lz_iii$d v(mainjack) v(fixjack1) v(fixjack2)
wrdata gm0x3_lz_iii_stati$d v(xls.xs) v(xlp.xs) v(dep) v(ina) v(vplus) v(vminus) v(main_a) v(mainc) v(fixc1) v(fixc2)
destroy all
echo "gm0x3_lz_iii_i,gm0x3_lz_iii.dat,l29d2_iii,1000,0,0a3,100k,1.0,8.0,19.0,1e-05,evento,g0sempre_lz_iii,g0mai_lz_iii,6.5,1,A_ins;B2" >> tb_v2_casopeggiore_manifest.csv
echo "gm0x3_lz_iii_c,gm0x3_lz_iii.dat,l29d2_iii,1000,0,0a3,100k,8.0,10.0,19.0,1e-05,evento,g3sempre_lz_iii,g3mai_lz_iii,0.0,1,A_ins;A_rel;B2" >> tb_v2_casopeggiore_manifest.csv
* ---- L29d2 1: gm3x0_lz_iii ----
alter vamp dc = 0
alter vfrq dc = 1000
alter rldm = 100k
alter rld1 = 100k
alter rld2 = 100k
alter vti dc = 1.0
alter vtr dc = 10.0
alter vtijk dc = 7.5
alter vtrjk dc = 10.0
alter vosa dc = 0
alter vosb dc = 0
alter vosf1 dc = 0
alter vosf2 dc = 0
alter ratth = 1m
alter rattb = 10k
alter rl1 = 845
alter cwire = 100p
alter vk1i dc = 1
alter vk1t dc = 8.000000
alter vk5i dc = 0
alter vk5t dc = 1000.000000
alter vt1ri dc = 1
alter vt1rt dc = 1000.000000
alter vt1si dc = 0
alter vt1st dc = 1000.000000
alter vt2ri dc = 1
alter vt2rt dc = 1000.000000
alter vt2si dc = 0
alter vt2st dc = 1000.000000
alter vtijk dc = 1000.000000
alter vtrjk dc = 2000.000000
alter vksa dc = 7.500000
alter vksb dc = 10.001000
alter vkca dc = 7.501000
alter vkcb dc = 10.000000
alter vtiser dc = -10
alter vtrser dc = 1000
alter rbym = 1e12
alter rby1 = 1e12
alter rby2 = 1e12
alter rbcm = 220k
alter rbc1 = 470k
alter rbc2 = 470k
alter cksm = 0.1p
alter cks1 = 0.1p
alter cks2 = 0.1p
alter ccavm = 1e-18
alter ccav1 = 1e-18
alter ccav2 = 1e-18
print @cksm[capacitance] @cks1[capacitance] @cks2[capacitance] @ccavm[capacitance] @ccav1[capacitance] @ccav2[capacitance]
tran 1e-05 19.0 0 1e-05
wrdata gm3x0_lz_iii$d v(mainjack) v(fixjack1) v(fixjack2)
wrdata gm3x0_lz_iii_stati$d v(xls.xs) v(xlp.xs) v(dep) v(ina) v(vplus) v(vminus) v(main_a) v(mainc) v(fixc1) v(fixc2)
destroy all
echo "gm3x0_lz_iii_i,gm3x0_lz_iii.dat,l29d2_iii,1000,0,3a0,100k,1.0,8.0,19.0,1e-05,evento,g3sempre_lz_iii,g3mai_lz_iii,6.5,1,A_ins;B2" >> tb_v2_casopeggiore_manifest.csv
echo "gm3x0_lz_iii_c,gm3x0_lz_iii.dat,l29d2_iii,1000,0,3a0,100k,8.0,10.0,19.0,1e-05,evento,g0sempre_lz_iii,g0mai_lz_iii,0.0,1,A_ins;A_rel;B2" >> tb_v2_casopeggiore_manifest.csv
* ---- L29d2 1: gm3x10_lz_iii ----
alter vamp dc = 0
alter vfrq dc = 1000
alter rldm = 100k
alter rld1 = 100k
alter rld2 = 100k
alter vti dc = 1.0
alter vtr dc = 10.0
alter vtijk dc = 7.5
alter vtrjk dc = 10.0
alter vosa dc = 0
alter vosb dc = 0
alter vosf1 dc = 0
alter vosf2 dc = 0
alter ratth = 1m
alter rattb = 10k
alter rl1 = 845
alter cwire = 100p
alter vk1i dc = 1
alter vk1t dc = 1000.000000
alter vk5i dc = 0
alter vk5t dc = 8.000000
alter vt1ri dc = 1
alter vt1rt dc = 1000.000000
alter vt1si dc = 0
alter vt1st dc = 1000.000000
alter vt2ri dc = 1
alter vt2rt dc = 1000.000000
alter vt2si dc = 0
alter vt2st dc = 1000.000000
alter vtijk dc = 1000.000000
alter vtrjk dc = 2000.000000
alter vksa dc = 7.500000
alter vksb dc = 10.001000
alter vkca dc = 7.501000
alter vkcb dc = 10.000000
alter vtiser dc = -10
alter vtrser dc = 1000
alter rbym = 1e12
alter rby1 = 1e12
alter rby2 = 1e12
alter rbcm = 220k
alter rbc1 = 470k
alter rbc2 = 470k
alter cksm = 0.1p
alter cks1 = 0.1p
alter cks2 = 0.1p
alter ccavm = 1e-18
alter ccav1 = 1e-18
alter ccav2 = 1e-18
print @cksm[capacitance] @cks1[capacitance] @cks2[capacitance] @ccavm[capacitance] @ccav1[capacitance] @ccav2[capacitance]
tran 1e-05 19.0 0 1e-05
wrdata gm3x10_lz_iii$d v(mainjack) v(fixjack1) v(fixjack2)
wrdata gm3x10_lz_iii_stati$d v(xls.xs) v(xlp.xs) v(dep) v(ina) v(vplus) v(vminus) v(main_a) v(mainc) v(fixc1) v(fixc2)
destroy all
echo "gm3x10_lz_iii_i,gm3x10_lz_iii.dat,l29d2_iii,1000,0,3a10,100k,1.0,8.0,19.0,1e-05,evento,g3sempre_lz_iii,g3mai_lz_iii,6.5,1,A_ins;B2" >> tb_v2_casopeggiore_manifest.csv
echo "gm3x10_lz_iii_c,gm3x10_lz_iii.dat,l29d2_iii,1000,0,3a10,100k,8.0,10.0,19.0,1e-05,evento,g10sempre_lz_iii,g10mai_lz_iii,0.0,1,A_ins;A_rel;B2" >> tb_v2_casopeggiore_manifest.csv
* ---- L29d2 1: gm10x3_lz_iii ----
alter vamp dc = 0
alter vfrq dc = 1000
alter rldm = 100k
alter rld1 = 100k
alter rld2 = 100k
alter vti dc = 1.0
alter vtr dc = 10.0
alter vtijk dc = 7.5
alter vtrjk dc = 10.0
alter vosa dc = 0
alter vosb dc = 0
alter vosf1 dc = 0
alter vosf2 dc = 0
alter ratth = 1m
alter rattb = 10k
alter rl1 = 845
alter cwire = 100p
alter vk1i dc = 1
alter vk1t dc = 1000.000000
alter vk5i dc = 1
alter vk5t dc = 8.000000
alter vt1ri dc = 1
alter vt1rt dc = 1000.000000
alter vt1si dc = 0
alter vt1st dc = 1000.000000
alter vt2ri dc = 1
alter vt2rt dc = 1000.000000
alter vt2si dc = 0
alter vt2st dc = 1000.000000
alter vtijk dc = 1000.000000
alter vtrjk dc = 2000.000000
alter vksa dc = 7.500000
alter vksb dc = 10.001000
alter vkca dc = 7.501000
alter vkcb dc = 10.000000
alter vtiser dc = -10
alter vtrser dc = 1000
alter rbym = 1e12
alter rby1 = 1e12
alter rby2 = 1e12
alter rbcm = 220k
alter rbc1 = 470k
alter rbc2 = 470k
alter cksm = 0.1p
alter cks1 = 0.1p
alter cks2 = 0.1p
alter ccavm = 1e-18
alter ccav1 = 1e-18
alter ccav2 = 1e-18
print @cksm[capacitance] @cks1[capacitance] @cks2[capacitance] @ccavm[capacitance] @ccav1[capacitance] @ccav2[capacitance]
tran 1e-05 19.0 0 1e-05
wrdata gm10x3_lz_iii$d v(mainjack) v(fixjack1) v(fixjack2)
wrdata gm10x3_lz_iii_stati$d v(xls.xs) v(xlp.xs) v(dep) v(ina) v(vplus) v(vminus) v(main_a) v(mainc) v(fixc1) v(fixc2)
destroy all
echo "gm10x3_lz_iii_i,gm10x3_lz_iii.dat,l29d2_iii,1000,0,10a3,100k,1.0,8.0,19.0,1e-05,evento,g10sempre_lz_iii,g10mai_lz_iii,6.5,1,A_ins;B2" >> tb_v2_casopeggiore_manifest.csv
echo "gm10x3_lz_iii_c,gm10x3_lz_iii.dat,l29d2_iii,1000,0,10a3,100k,8.0,10.0,19.0,1e-05,evento,g3sempre_lz_iii,g3mai_lz_iii,0.0,1,A_ins;A_rel;B2" >> tb_v2_casopeggiore_manifest.csv
* ---- L29d2 1: gm0x10_lz_iii ----
alter vamp dc = 0
alter vfrq dc = 1000
alter rldm = 100k
alter rld1 = 100k
alter rld2 = 100k
alter vti dc = 1.0
alter vtr dc = 10.0
alter vtijk dc = 7.5
alter vtrjk dc = 10.0
alter vosa dc = 0
alter vosb dc = 0
alter vosf1 dc = 0
alter vosf2 dc = 0
alter ratth = 1m
alter rattb = 10k
alter rl1 = 845
alter cwire = 100p
alter vk1i dc = 0
alter vk1t dc = 8.000300
alter vk5i dc = 0
alter vk5t dc = 8.000000
alter vt1ri dc = 1
alter vt1rt dc = 1000.000000
alter vt1si dc = 0
alter vt1st dc = 1000.000000
alter vt2ri dc = 1
alter vt2rt dc = 1000.000000
alter vt2si dc = 0
alter vt2st dc = 1000.000000
alter vtijk dc = 1000.000000
alter vtrjk dc = 2000.000000
alter vksa dc = 7.500000
alter vksb dc = 10.001000
alter vkca dc = 7.501000
alter vkcb dc = 10.000000
alter vtiser dc = -10
alter vtrser dc = 1000
alter rbym = 1e12
alter rby1 = 1e12
alter rby2 = 1e12
alter rbcm = 220k
alter rbc1 = 470k
alter rbc2 = 470k
alter cksm = 0.1p
alter cks1 = 0.1p
alter cks2 = 0.1p
alter ccavm = 1e-18
alter ccav1 = 1e-18
alter ccav2 = 1e-18
print @cksm[capacitance] @cks1[capacitance] @cks2[capacitance] @ccavm[capacitance] @ccav1[capacitance] @ccav2[capacitance]
tran 1e-05 19.0 0 1e-05
wrdata gm0x10_lz_iii$d v(mainjack) v(fixjack1) v(fixjack2)
wrdata gm0x10_lz_iii_stati$d v(xls.xs) v(xlp.xs) v(dep) v(ina) v(vplus) v(vminus) v(main_a) v(mainc) v(fixc1) v(fixc2)
destroy all
echo "gm0x10_lz_iii_i,gm0x10_lz_iii.dat,l29d2_iii,1000,0,0a10,100k,1.0,8.0,19.0,1e-05,evento,g0sempre_lz_iii,g0mai_lz_iii,6.5,1,A_ins;B2" >> tb_v2_casopeggiore_manifest.csv
echo "gm0x10_lz_iii_c,gm0x10_lz_iii.dat,l29d2_iii,1000,0,0a10,100k,8.0,10.0,19.0,1e-05,evento,g10sempre_lz_iii,g10mai_lz_iii,0.0,1,A_ins;A_rel;B2" >> tb_v2_casopeggiore_manifest.csv
* ---- L29d2 1: gm10x0_lz_iii ----
alter vamp dc = 0
alter vfrq dc = 1000
alter rldm = 100k
alter rld1 = 100k
alter rld2 = 100k
alter vti dc = 1.0
alter vtr dc = 10.0
alter vtijk dc = 7.5
alter vtrjk dc = 10.0
alter vosa dc = 0
alter vosb dc = 0
alter vosf1 dc = 0
alter vosf2 dc = 0
alter ratth = 1m
alter rattb = 10k
alter rl1 = 845
alter cwire = 100p
alter vk1i dc = 1
alter vk1t dc = 8.000000
alter vk5i dc = 1
alter vk5t dc = 8.000300
alter vt1ri dc = 1
alter vt1rt dc = 1000.000000
alter vt1si dc = 0
alter vt1st dc = 1000.000000
alter vt2ri dc = 1
alter vt2rt dc = 1000.000000
alter vt2si dc = 0
alter vt2st dc = 1000.000000
alter vtijk dc = 1000.000000
alter vtrjk dc = 2000.000000
alter vksa dc = 7.500000
alter vksb dc = 10.001000
alter vkca dc = 7.501000
alter vkcb dc = 10.000000
alter vtiser dc = -10
alter vtrser dc = 1000
alter rbym = 1e12
alter rby1 = 1e12
alter rby2 = 1e12
alter rbcm = 220k
alter rbc1 = 470k
alter rbc2 = 470k
alter cksm = 0.1p
alter cks1 = 0.1p
alter cks2 = 0.1p
alter ccavm = 1e-18
alter ccav1 = 1e-18
alter ccav2 = 1e-18
print @cksm[capacitance] @cks1[capacitance] @cks2[capacitance] @ccavm[capacitance] @ccav1[capacitance] @ccav2[capacitance]
tran 1e-05 19.0 0 1e-05
wrdata gm10x0_lz_iii$d v(mainjack) v(fixjack1) v(fixjack2)
wrdata gm10x0_lz_iii_stati$d v(xls.xs) v(xlp.xs) v(dep) v(ina) v(vplus) v(vminus) v(main_a) v(mainc) v(fixc1) v(fixc2)
destroy all
echo "gm10x0_lz_iii_i,gm10x0_lz_iii.dat,l29d2_iii,1000,0,10a0,100k,1.0,8.0,19.0,1e-05,evento,g10sempre_lz_iii,g10mai_lz_iii,6.5,1,A_ins;B2" >> tb_v2_casopeggiore_manifest.csv
echo "gm10x0_lz_iii_c,gm10x0_lz_iii.dat,l29d2_iii,1000,0,10a0,100k,8.0,10.0,19.0,1e-05,evento,g0sempre_lz_iii,g0mai_lz_iii,0.0,1,A_ins;A_rel;B2" >> tb_v2_casopeggiore_manifest.csv
alter vamp dc = 0
alter vfrq dc = 1000
alter rldm = 100k
alter rld1 = 100k
alter rld2 = 100k
alter vti dc = 1.0
alter vtr dc = 10.0
alter vtijk dc = 7.5
alter vtrjk dc = 10.0
alter vosa dc = 0
alter vosb dc = 0
alter vosf1 dc = 0
alter vosf2 dc = 0
alter ratth = 1m
alter rattb = 10k
alter rl1 = 845
alter cwire = 100p
alter vk1i dc = 0
alter vk1t dc = 8.000300
alter vk5i dc = 0
alter vk5t dc = 8.000000
alter vt1ri dc = 1
alter vt1rt dc = 1000.000000
alter vt1si dc = 0
alter vt1st dc = 1000.000000
alter vt2ri dc = 1
alter vt2rt dc = 1000.000000
alter vt2si dc = 0
alter vt2st dc = 1000.000000
alter vtijk dc = 1000.000000
alter vtrjk dc = 2000.000000
alter vksa dc = 7.500000
alter vksb dc = 10.001000
alter vkca dc = 7.501000
alter vkcb dc = 10.000000
alter vtiser dc = -10
alter vtrser dc = 1000
alter rbym = 1e12
alter rby1 = 1e12
alter rby2 = 1e12
alter rbcm = 220k
alter rbc1 = 470k
alter rbc2 = 470k
alter cksm = 0.1p
alter cks1 = 0.1p
alter cks2 = 0.1p
alter ccavm = 1e-18
alter ccav1 = 1e-18
alter ccav2 = 1e-18
print @cksm[capacitance] @cks1[capacitance] @cks2[capacitance] @ccavm[capacitance] @ccav1[capacitance] @ccav2[capacitance]
tran 7e-06 19.0 0 7e-06
wrdata gm0x10p_lz_iii$d v(mainjack) v(fixjack1) v(fixjack2)
destroy all
echo "pav_gm0x10_0_iii,gm0x10p_lz_iii.dat,pavimento,1000,0,0a10,100k,1.0,1000,19.0,7e-06,pav_num,gm0x10_lz_iii_i,-,0.0,0," >> tb_v2_casopeggiore_manifest.csv
echo "pav_gm0x10_1_iii,gm0x10p_lz_iii.dat,pavimento,1000,0,0a10,100k,8.0,1000,19.0,7e-06,pav_num,gm0x10_lz_iii_i,-,0.0,0," >> tb_v2_casopeggiore_manifest.csv
echo "pav_gm0x10_2_iii,gm0x10p_lz_iii.dat,pavimento,1000,0,0a10,100k,10.0,1000,19.0,7e-06,pav_num,gm0x10_lz_iii_i,-,0.0,0," >> tb_v2_casopeggiore_manifest.csv
* ---- L29d2 2: tm0x6_1k_iii ----
alter vamp dc = 3.818
alter vfrq dc = 1000
alter rldm = 100k
alter rld1 = 100k
alter rld2 = 100k
alter vti dc = 1.0
alter vtr dc = 10.0
alter vtijk dc = 7.5
alter vtrjk dc = 10.0
alter vosa dc = 0
alter vosb dc = 0
alter vosf1 dc = 0
alter vosf2 dc = 0
alter ratth = 1m
alter rattb = 10k
alter rl1 = 845
alter cwire = 100p
alter vk1i dc = 1
alter vk1t dc = 1000.000000
alter vk5i dc = 1
alter vk5t dc = 1000.000000
alter vt1ri dc = 1
alter vt1rt dc = 8.000000
alter vt1si dc = 0
alter vt1st dc = 8.001000
alter vt2ri dc = 1
alter vt2rt dc = 1000.000000
alter vt2si dc = 0
alter vt2st dc = 1000.000000
alter vtijk dc = 1000.000000
alter vtrjk dc = 2000.000000
alter vksa dc = 7.500000
alter vksb dc = 10.001000
alter vkca dc = 7.501000
alter vkcb dc = 10.000000
alter vtiser dc = -10
alter vtrser dc = 1000
alter rbym = 1e12
alter rby1 = 1e12
alter rby2 = 1e12
alter rbcm = 220k
alter rbc1 = 470k
alter rbc2 = 470k
alter cksm = 0.1p
alter cks1 = 0.1p
alter cks2 = 0.1p
alter ccavm = 1e-18
alter ccav1 = 1e-18
alter ccav2 = 1e-18
print @cksm[capacitance] @cks1[capacitance] @cks2[capacitance] @ccavm[capacitance] @ccav1[capacitance] @ccav2[capacitance]
tran 1e-05 19.0 0 1e-05
wrdata tm0x6_1k_iii$d v(mainjack) v(fixjack1) v(fixjack2)
wrdata tm0x6_1k_iii_stati$d v(xls.xs) v(xlp.xs) v(dep) v(ina) v(vplus) v(vminus) v(main_a) v(mainc) v(fixc1) v(fixc2)
destroy all
echo "tm0x6_1k_iii_i,tm0x6_1k_iii.dat,l29d2_iii,1000,3.818,t0a6,100k,1.0,8.0,19.0,1e-05,evento,g10sempre_1k_iii,g10mai_1k_iii,6.5,2,S_ins;B2" >> tb_v2_casopeggiore_manifest.csv
echo "tm0x6_1k_iii_c,tm0x6_1k_iii.dat,l29d2_iii,1000,3.818,t0a6,100k,8.0,10.0,19.0,1e-05,evento,t6sempre_1k_iii,t6mai_1k_iii,0.0,2,S_rel;B2" >> tb_v2_casopeggiore_manifest.csv
* ---- L29d2 2: tm6x0_1k_iii ----
alter vamp dc = 3.818
alter vfrq dc = 1000
alter rldm = 100k
alter rld1 = 100k
alter rld2 = 100k
alter vti dc = 1.0
alter vtr dc = 10.0
alter vtijk dc = 7.5
alter vtrjk dc = 10.0
alter vosa dc = 0
alter vosb dc = 0
alter vosf1 dc = 0
alter vosf2 dc = 0
alter ratth = 1m
alter rattb = 10k
alter rl1 = 845
alter cwire = 100p
alter vk1i dc = 1
alter vk1t dc = 1000.000000
alter vk5i dc = 1
alter vk5t dc = 1000.000000
alter vt1ri dc = 0
alter vt1rt dc = 8.001000
alter vt1si dc = 1
alter vt1st dc = 8.000000
alter vt2ri dc = 1
alter vt2rt dc = 1000.000000
alter vt2si dc = 0
alter vt2st dc = 1000.000000
alter vtijk dc = 1000.000000
alter vtrjk dc = 2000.000000
alter vksa dc = 7.500000
alter vksb dc = 10.001000
alter vkca dc = 7.501000
alter vkcb dc = 10.000000
alter vtiser dc = -10
alter vtrser dc = 1000
alter rbym = 1e12
alter rby1 = 1e12
alter rby2 = 1e12
alter rbcm = 220k
alter rbc1 = 470k
alter rbc2 = 470k
alter cksm = 0.1p
alter cks1 = 0.1p
alter cks2 = 0.1p
alter ccavm = 1e-18
alter ccav1 = 1e-18
alter ccav2 = 1e-18
print @cksm[capacitance] @cks1[capacitance] @cks2[capacitance] @ccavm[capacitance] @ccav1[capacitance] @ccav2[capacitance]
tran 1e-05 19.0 0 1e-05
wrdata tm6x0_1k_iii$d v(mainjack) v(fixjack1) v(fixjack2)
wrdata tm6x0_1k_iii_stati$d v(xls.xs) v(xlp.xs) v(dep) v(ina) v(vplus) v(vminus) v(main_a) v(mainc) v(fixc1) v(fixc2)
destroy all
echo "tm6x0_1k_iii_i,tm6x0_1k_iii.dat,l29d2_iii,1000,3.818,t6a0,100k,1.0,8.0,19.0,1e-05,evento,t6sempre_1k_iii,t6mai_1k_iii,6.5,2,S_ins;B2" >> tb_v2_casopeggiore_manifest.csv
echo "tm6x0_1k_iii_c,tm6x0_1k_iii.dat,l29d2_iii,1000,3.818,t6a0,100k,8.0,10.0,19.0,1e-05,evento,g10sempre_1k_iii,g10mai_1k_iii,0.0,2,S_rel;B2" >> tb_v2_casopeggiore_manifest.csv
* ---- L29d2 2: tm6x12_1k_iii ----
alter vamp dc = 3.818
alter vfrq dc = 1000
alter rldm = 100k
alter rld1 = 100k
alter rld2 = 100k
alter vti dc = 1.0
alter vtr dc = 10.0
alter vtijk dc = 7.5
alter vtrjk dc = 10.0
alter vosa dc = 0
alter vosb dc = 0
alter vosf1 dc = 0
alter vosf2 dc = 0
alter ratth = 1m
alter rattb = 10k
alter rl1 = 845
alter cwire = 100p
alter vk1i dc = 1
alter vk1t dc = 1000.000000
alter vk5i dc = 1
alter vk5t dc = 1000.000000
alter vt1ri dc = 0
alter vt1rt dc = 1000.000000
alter vt1si dc = 1
alter vt1st dc = 1000.000000
alter vt2ri dc = 1
alter vt2rt dc = 8.000000
alter vt2si dc = 0
alter vt2st dc = 8.001000
alter vtijk dc = 1000.000000
alter vtrjk dc = 2000.000000
alter vksa dc = 7.500000
alter vksb dc = 10.001000
alter vkca dc = 7.501000
alter vkcb dc = 10.000000
alter vtiser dc = -10
alter vtrser dc = 1000
alter rbym = 1e12
alter rby1 = 1e12
alter rby2 = 1e12
alter rbcm = 220k
alter rbc1 = 470k
alter rbc2 = 470k
alter cksm = 0.1p
alter cks1 = 0.1p
alter cks2 = 0.1p
alter ccavm = 1e-18
alter ccav1 = 1e-18
alter ccav2 = 1e-18
print @cksm[capacitance] @cks1[capacitance] @cks2[capacitance] @ccavm[capacitance] @ccav1[capacitance] @ccav2[capacitance]
tran 1e-05 19.0 0 1e-05
wrdata tm6x12_1k_iii$d v(mainjack) v(fixjack1) v(fixjack2)
wrdata tm6x12_1k_iii_stati$d v(xls.xs) v(xlp.xs) v(dep) v(ina) v(vplus) v(vminus) v(main_a) v(mainc) v(fixc1) v(fixc2)
destroy all
echo "tm6x12_1k_iii_i,tm6x12_1k_iii.dat,l29d2_iii,1000,3.818,t6a12,100k,1.0,8.0,19.0,1e-05,evento,t6sempre_1k_iii,t6mai_1k_iii,6.5,2,S_ins;B2" >> tb_v2_casopeggiore_manifest.csv
echo "tm6x12_1k_iii_c,tm6x12_1k_iii.dat,l29d2_iii,1000,3.818,t6a12,100k,8.0,10.0,19.0,1e-05,evento,t12sempre_1k_iii,t12mai_1k_iii,0.0,2,S_rel;B2" >> tb_v2_casopeggiore_manifest.csv
* ---- L29d2 2: tm12x6_1k_iii ----
alter vamp dc = 3.818
alter vfrq dc = 1000
alter rldm = 100k
alter rld1 = 100k
alter rld2 = 100k
alter vti dc = 1.0
alter vtr dc = 10.0
alter vtijk dc = 7.5
alter vtrjk dc = 10.0
alter vosa dc = 0
alter vosb dc = 0
alter vosf1 dc = 0
alter vosf2 dc = 0
alter ratth = 1m
alter rattb = 10k
alter rl1 = 845
alter cwire = 100p
alter vk1i dc = 1
alter vk1t dc = 1000.000000
alter vk5i dc = 1
alter vk5t dc = 1000.000000
alter vt1ri dc = 0
alter vt1rt dc = 1000.000000
alter vt1si dc = 1
alter vt1st dc = 1000.000000
alter vt2ri dc = 0
alter vt2rt dc = 8.001000
alter vt2si dc = 1
alter vt2st dc = 8.000000
alter vtijk dc = 1000.000000
alter vtrjk dc = 2000.000000
alter vksa dc = 7.500000
alter vksb dc = 10.001000
alter vkca dc = 7.501000
alter vkcb dc = 10.000000
alter vtiser dc = -10
alter vtrser dc = 1000
alter rbym = 1e12
alter rby1 = 1e12
alter rby2 = 1e12
alter rbcm = 220k
alter rbc1 = 470k
alter rbc2 = 470k
alter cksm = 0.1p
alter cks1 = 0.1p
alter cks2 = 0.1p
alter ccavm = 1e-18
alter ccav1 = 1e-18
alter ccav2 = 1e-18
print @cksm[capacitance] @cks1[capacitance] @cks2[capacitance] @ccavm[capacitance] @ccav1[capacitance] @ccav2[capacitance]
tran 1e-05 19.0 0 1e-05
wrdata tm12x6_1k_iii$d v(mainjack) v(fixjack1) v(fixjack2)
wrdata tm12x6_1k_iii_stati$d v(xls.xs) v(xlp.xs) v(dep) v(ina) v(vplus) v(vminus) v(main_a) v(mainc) v(fixc1) v(fixc2)
destroy all
echo "tm12x6_1k_iii_i,tm12x6_1k_iii.dat,l29d2_iii,1000,3.818,t12a6,100k,1.0,8.0,19.0,1e-05,evento,t12sempre_1k_iii,t12mai_1k_iii,6.5,2,S_ins;B2" >> tb_v2_casopeggiore_manifest.csv
echo "tm12x6_1k_iii_c,tm12x6_1k_iii.dat,l29d2_iii,1000,3.818,t12a6,100k,8.0,10.0,19.0,1e-05,evento,t6sempre_1k_iii,t6mai_1k_iii,0.0,2,S_rel;B2" >> tb_v2_casopeggiore_manifest.csv
* ---- L29d2 2: tm0x12_1k_iii ----
alter vamp dc = 3.818
alter vfrq dc = 1000
alter rldm = 100k
alter rld1 = 100k
alter rld2 = 100k
alter vti dc = 1.0
alter vtr dc = 10.0
alter vtijk dc = 7.5
alter vtrjk dc = 10.0
alter vosa dc = 0
alter vosb dc = 0
alter vosf1 dc = 0
alter vosf2 dc = 0
alter ratth = 1m
alter rattb = 10k
alter rl1 = 845
alter cwire = 100p
alter vk1i dc = 1
alter vk1t dc = 1000.000000
alter vk5i dc = 1
alter vk5t dc = 1000.000000
alter vt1ri dc = 1
alter vt1rt dc = 8.000000
alter vt1si dc = 0
alter vt1st dc = 8.001000
alter vt2ri dc = 1
alter vt2rt dc = 8.000000
alter vt2si dc = 0
alter vt2st dc = 8.001000
alter vtijk dc = 1000.000000
alter vtrjk dc = 2000.000000
alter vksa dc = 7.500000
alter vksb dc = 10.001000
alter vkca dc = 7.501000
alter vkcb dc = 10.000000
alter vtiser dc = -10
alter vtrser dc = 1000
alter rbym = 1e12
alter rby1 = 1e12
alter rby2 = 1e12
alter rbcm = 220k
alter rbc1 = 470k
alter rbc2 = 470k
alter cksm = 0.1p
alter cks1 = 0.1p
alter cks2 = 0.1p
alter ccavm = 1e-18
alter ccav1 = 1e-18
alter ccav2 = 1e-18
print @cksm[capacitance] @cks1[capacitance] @cks2[capacitance] @ccavm[capacitance] @ccav1[capacitance] @ccav2[capacitance]
tran 1e-05 19.0 0 1e-05
wrdata tm0x12_1k_iii$d v(mainjack) v(fixjack1) v(fixjack2)
wrdata tm0x12_1k_iii_stati$d v(xls.xs) v(xlp.xs) v(dep) v(ina) v(vplus) v(vminus) v(main_a) v(mainc) v(fixc1) v(fixc2)
destroy all
echo "tm0x12_1k_iii_i,tm0x12_1k_iii.dat,l29d2_iii,1000,3.818,t0a12,100k,1.0,8.0,19.0,1e-05,evento,g10sempre_1k_iii,g10mai_1k_iii,6.5,2,S_ins;B2" >> tb_v2_casopeggiore_manifest.csv
echo "tm0x12_1k_iii_c,tm0x12_1k_iii.dat,l29d2_iii,1000,3.818,t0a12,100k,8.0,10.0,19.0,1e-05,evento,t12sempre_1k_iii,t12mai_1k_iii,0.0,2,S_rel;B2" >> tb_v2_casopeggiore_manifest.csv
* ---- L29d2 2: tm12x0_1k_iii ----
alter vamp dc = 3.818
alter vfrq dc = 1000
alter rldm = 100k
alter rld1 = 100k
alter rld2 = 100k
alter vti dc = 1.0
alter vtr dc = 10.0
alter vtijk dc = 7.5
alter vtrjk dc = 10.0
alter vosa dc = 0
alter vosb dc = 0
alter vosf1 dc = 0
alter vosf2 dc = 0
alter ratth = 1m
alter rattb = 10k
alter rl1 = 845
alter cwire = 100p
alter vk1i dc = 1
alter vk1t dc = 1000.000000
alter vk5i dc = 1
alter vk5t dc = 1000.000000
alter vt1ri dc = 0
alter vt1rt dc = 8.001000
alter vt1si dc = 1
alter vt1st dc = 8.000000
alter vt2ri dc = 0
alter vt2rt dc = 8.001000
alter vt2si dc = 1
alter vt2st dc = 8.000000
alter vtijk dc = 1000.000000
alter vtrjk dc = 2000.000000
alter vksa dc = 7.500000
alter vksb dc = 10.001000
alter vkca dc = 7.501000
alter vkcb dc = 10.000000
alter vtiser dc = -10
alter vtrser dc = 1000
alter rbym = 1e12
alter rby1 = 1e12
alter rby2 = 1e12
alter rbcm = 220k
alter rbc1 = 470k
alter rbc2 = 470k
alter cksm = 0.1p
alter cks1 = 0.1p
alter cks2 = 0.1p
alter ccavm = 1e-18
alter ccav1 = 1e-18
alter ccav2 = 1e-18
print @cksm[capacitance] @cks1[capacitance] @cks2[capacitance] @ccavm[capacitance] @ccav1[capacitance] @ccav2[capacitance]
tran 1e-05 19.0 0 1e-05
wrdata tm12x0_1k_iii$d v(mainjack) v(fixjack1) v(fixjack2)
wrdata tm12x0_1k_iii_stati$d v(xls.xs) v(xlp.xs) v(dep) v(ina) v(vplus) v(vminus) v(main_a) v(mainc) v(fixc1) v(fixc2)
destroy all
echo "tm12x0_1k_iii_i,tm12x0_1k_iii.dat,l29d2_iii,1000,3.818,t12a0,100k,1.0,8.0,19.0,1e-05,evento,t12sempre_1k_iii,t12mai_1k_iii,6.5,2,S_ins;B2" >> tb_v2_casopeggiore_manifest.csv
echo "tm12x0_1k_iii_c,tm12x0_1k_iii.dat,l29d2_iii,1000,3.818,t12a0,100k,8.0,10.0,19.0,1e-05,evento,g10sempre_1k_iii,g10mai_1k_iii,0.0,2,S_rel;B2" >> tb_v2_casopeggiore_manifest.csv
* ---- L29d2 2: tm0x6_lz_iii ----
alter vamp dc = 0
alter vfrq dc = 1000
alter rldm = 100k
alter rld1 = 100k
alter rld2 = 100k
alter vti dc = 1.0
alter vtr dc = 10.0
alter vtijk dc = 7.5
alter vtrjk dc = 10.0
alter vosa dc = 0
alter vosb dc = 0
alter vosf1 dc = 0
alter vosf2 dc = 0
alter ratth = 1m
alter rattb = 10k
alter rl1 = 845
alter cwire = 100p
alter vk1i dc = 1
alter vk1t dc = 1000.000000
alter vk5i dc = 1
alter vk5t dc = 1000.000000
alter vt1ri dc = 1
alter vt1rt dc = 8.000000
alter vt1si dc = 0
alter vt1st dc = 8.001000
alter vt2ri dc = 1
alter vt2rt dc = 1000.000000
alter vt2si dc = 0
alter vt2st dc = 1000.000000
alter vtijk dc = 1000.000000
alter vtrjk dc = 2000.000000
alter vksa dc = 7.500000
alter vksb dc = 10.001000
alter vkca dc = 7.501000
alter vkcb dc = 10.000000
alter vtiser dc = -10
alter vtrser dc = 1000
alter rbym = 1e12
alter rby1 = 1e12
alter rby2 = 1e12
alter rbcm = 220k
alter rbc1 = 470k
alter rbc2 = 470k
alter cksm = 0.1p
alter cks1 = 0.1p
alter cks2 = 0.1p
alter ccavm = 1e-18
alter ccav1 = 1e-18
alter ccav2 = 1e-18
print @cksm[capacitance] @cks1[capacitance] @cks2[capacitance] @ccavm[capacitance] @ccav1[capacitance] @ccav2[capacitance]
tran 1e-05 19.0 0 1e-05
wrdata tm0x6_lz_iii$d v(mainjack) v(fixjack1) v(fixjack2)
wrdata tm0x6_lz_iii_stati$d v(xls.xs) v(xlp.xs) v(dep) v(ina) v(vplus) v(vminus) v(main_a) v(mainc) v(fixc1) v(fixc2)
destroy all
echo "tm0x6_lz_iii_i,tm0x6_lz_iii.dat,l29d2_iii,1000,0,t0a6,100k,1.0,8.0,19.0,1e-05,evento,g10sempre_lz_iii,g10mai_lz_iii,6.5,2,A_ins;B2" >> tb_v2_casopeggiore_manifest.csv
echo "tm0x6_lz_iii_c,tm0x6_lz_iii.dat,l29d2_iii,1000,0,t0a6,100k,8.0,10.0,19.0,1e-05,evento,t6sempre_lz_iii,t6mai_lz_iii,0.0,2,A_ins;A_rel;B2" >> tb_v2_casopeggiore_manifest.csv
* ---- L29d2 2: tm6x0_lz_iii ----
alter vamp dc = 0
alter vfrq dc = 1000
alter rldm = 100k
alter rld1 = 100k
alter rld2 = 100k
alter vti dc = 1.0
alter vtr dc = 10.0
alter vtijk dc = 7.5
alter vtrjk dc = 10.0
alter vosa dc = 0
alter vosb dc = 0
alter vosf1 dc = 0
alter vosf2 dc = 0
alter ratth = 1m
alter rattb = 10k
alter rl1 = 845
alter cwire = 100p
alter vk1i dc = 1
alter vk1t dc = 1000.000000
alter vk5i dc = 1
alter vk5t dc = 1000.000000
alter vt1ri dc = 0
alter vt1rt dc = 8.001000
alter vt1si dc = 1
alter vt1st dc = 8.000000
alter vt2ri dc = 1
alter vt2rt dc = 1000.000000
alter vt2si dc = 0
alter vt2st dc = 1000.000000
alter vtijk dc = 1000.000000
alter vtrjk dc = 2000.000000
alter vksa dc = 7.500000
alter vksb dc = 10.001000
alter vkca dc = 7.501000
alter vkcb dc = 10.000000
alter vtiser dc = -10
alter vtrser dc = 1000
alter rbym = 1e12
alter rby1 = 1e12
alter rby2 = 1e12
alter rbcm = 220k
alter rbc1 = 470k
alter rbc2 = 470k
alter cksm = 0.1p
alter cks1 = 0.1p
alter cks2 = 0.1p
alter ccavm = 1e-18
alter ccav1 = 1e-18
alter ccav2 = 1e-18
print @cksm[capacitance] @cks1[capacitance] @cks2[capacitance] @ccavm[capacitance] @ccav1[capacitance] @ccav2[capacitance]
tran 1e-05 19.0 0 1e-05
wrdata tm6x0_lz_iii$d v(mainjack) v(fixjack1) v(fixjack2)
wrdata tm6x0_lz_iii_stati$d v(xls.xs) v(xlp.xs) v(dep) v(ina) v(vplus) v(vminus) v(main_a) v(mainc) v(fixc1) v(fixc2)
destroy all
echo "tm6x0_lz_iii_i,tm6x0_lz_iii.dat,l29d2_iii,1000,0,t6a0,100k,1.0,8.0,19.0,1e-05,evento,t6sempre_lz_iii,t6mai_lz_iii,6.5,2,A_ins;B2" >> tb_v2_casopeggiore_manifest.csv
echo "tm6x0_lz_iii_c,tm6x0_lz_iii.dat,l29d2_iii,1000,0,t6a0,100k,8.0,10.0,19.0,1e-05,evento,g10sempre_lz_iii,g10mai_lz_iii,0.0,2,A_ins;A_rel;B2" >> tb_v2_casopeggiore_manifest.csv
* ---- L29d2 2: tm6x12_lz_iii ----
alter vamp dc = 0
alter vfrq dc = 1000
alter rldm = 100k
alter rld1 = 100k
alter rld2 = 100k
alter vti dc = 1.0
alter vtr dc = 10.0
alter vtijk dc = 7.5
alter vtrjk dc = 10.0
alter vosa dc = 0
alter vosb dc = 0
alter vosf1 dc = 0
alter vosf2 dc = 0
alter ratth = 1m
alter rattb = 10k
alter rl1 = 845
alter cwire = 100p
alter vk1i dc = 1
alter vk1t dc = 1000.000000
alter vk5i dc = 1
alter vk5t dc = 1000.000000
alter vt1ri dc = 0
alter vt1rt dc = 1000.000000
alter vt1si dc = 1
alter vt1st dc = 1000.000000
alter vt2ri dc = 1
alter vt2rt dc = 8.000000
alter vt2si dc = 0
alter vt2st dc = 8.001000
alter vtijk dc = 1000.000000
alter vtrjk dc = 2000.000000
alter vksa dc = 7.500000
alter vksb dc = 10.001000
alter vkca dc = 7.501000
alter vkcb dc = 10.000000
alter vtiser dc = -10
alter vtrser dc = 1000
alter rbym = 1e12
alter rby1 = 1e12
alter rby2 = 1e12
alter rbcm = 220k
alter rbc1 = 470k
alter rbc2 = 470k
alter cksm = 0.1p
alter cks1 = 0.1p
alter cks2 = 0.1p
alter ccavm = 1e-18
alter ccav1 = 1e-18
alter ccav2 = 1e-18
print @cksm[capacitance] @cks1[capacitance] @cks2[capacitance] @ccavm[capacitance] @ccav1[capacitance] @ccav2[capacitance]
tran 1e-05 19.0 0 1e-05
wrdata tm6x12_lz_iii$d v(mainjack) v(fixjack1) v(fixjack2)
wrdata tm6x12_lz_iii_stati$d v(xls.xs) v(xlp.xs) v(dep) v(ina) v(vplus) v(vminus) v(main_a) v(mainc) v(fixc1) v(fixc2)
destroy all
echo "tm6x12_lz_iii_i,tm6x12_lz_iii.dat,l29d2_iii,1000,0,t6a12,100k,1.0,8.0,19.0,1e-05,evento,t6sempre_lz_iii,t6mai_lz_iii,6.5,2,A_ins;B2" >> tb_v2_casopeggiore_manifest.csv
echo "tm6x12_lz_iii_c,tm6x12_lz_iii.dat,l29d2_iii,1000,0,t6a12,100k,8.0,10.0,19.0,1e-05,evento,t12sempre_lz_iii,t12mai_lz_iii,0.0,2,A_ins;A_rel;B2" >> tb_v2_casopeggiore_manifest.csv
* ---- L29d2 2: tm12x6_lz_iii ----
alter vamp dc = 0
alter vfrq dc = 1000
alter rldm = 100k
alter rld1 = 100k
alter rld2 = 100k
alter vti dc = 1.0
alter vtr dc = 10.0
alter vtijk dc = 7.5
alter vtrjk dc = 10.0
alter vosa dc = 0
alter vosb dc = 0
alter vosf1 dc = 0
alter vosf2 dc = 0
alter ratth = 1m
alter rattb = 10k
alter rl1 = 845
alter cwire = 100p
alter vk1i dc = 1
alter vk1t dc = 1000.000000
alter vk5i dc = 1
alter vk5t dc = 1000.000000
alter vt1ri dc = 0
alter vt1rt dc = 1000.000000
alter vt1si dc = 1
alter vt1st dc = 1000.000000
alter vt2ri dc = 0
alter vt2rt dc = 8.001000
alter vt2si dc = 1
alter vt2st dc = 8.000000
alter vtijk dc = 1000.000000
alter vtrjk dc = 2000.000000
alter vksa dc = 7.500000
alter vksb dc = 10.001000
alter vkca dc = 7.501000
alter vkcb dc = 10.000000
alter vtiser dc = -10
alter vtrser dc = 1000
alter rbym = 1e12
alter rby1 = 1e12
alter rby2 = 1e12
alter rbcm = 220k
alter rbc1 = 470k
alter rbc2 = 470k
alter cksm = 0.1p
alter cks1 = 0.1p
alter cks2 = 0.1p
alter ccavm = 1e-18
alter ccav1 = 1e-18
alter ccav2 = 1e-18
print @cksm[capacitance] @cks1[capacitance] @cks2[capacitance] @ccavm[capacitance] @ccav1[capacitance] @ccav2[capacitance]
tran 1e-05 19.0 0 1e-05
wrdata tm12x6_lz_iii$d v(mainjack) v(fixjack1) v(fixjack2)
wrdata tm12x6_lz_iii_stati$d v(xls.xs) v(xlp.xs) v(dep) v(ina) v(vplus) v(vminus) v(main_a) v(mainc) v(fixc1) v(fixc2)
destroy all
echo "tm12x6_lz_iii_i,tm12x6_lz_iii.dat,l29d2_iii,1000,0,t12a6,100k,1.0,8.0,19.0,1e-05,evento,t12sempre_lz_iii,t12mai_lz_iii,6.5,2,A_ins;B2" >> tb_v2_casopeggiore_manifest.csv
echo "tm12x6_lz_iii_c,tm12x6_lz_iii.dat,l29d2_iii,1000,0,t12a6,100k,8.0,10.0,19.0,1e-05,evento,t6sempre_lz_iii,t6mai_lz_iii,0.0,2,A_ins;A_rel;B2" >> tb_v2_casopeggiore_manifest.csv
* ---- L29d2 2: tm0x12_lz_iii ----
alter vamp dc = 0
alter vfrq dc = 1000
alter rldm = 100k
alter rld1 = 100k
alter rld2 = 100k
alter vti dc = 1.0
alter vtr dc = 10.0
alter vtijk dc = 7.5
alter vtrjk dc = 10.0
alter vosa dc = 0
alter vosb dc = 0
alter vosf1 dc = 0
alter vosf2 dc = 0
alter ratth = 1m
alter rattb = 10k
alter rl1 = 845
alter cwire = 100p
alter vk1i dc = 1
alter vk1t dc = 1000.000000
alter vk5i dc = 1
alter vk5t dc = 1000.000000
alter vt1ri dc = 1
alter vt1rt dc = 8.000000
alter vt1si dc = 0
alter vt1st dc = 8.001000
alter vt2ri dc = 1
alter vt2rt dc = 8.000000
alter vt2si dc = 0
alter vt2st dc = 8.001000
alter vtijk dc = 1000.000000
alter vtrjk dc = 2000.000000
alter vksa dc = 7.500000
alter vksb dc = 10.001000
alter vkca dc = 7.501000
alter vkcb dc = 10.000000
alter vtiser dc = -10
alter vtrser dc = 1000
alter rbym = 1e12
alter rby1 = 1e12
alter rby2 = 1e12
alter rbcm = 220k
alter rbc1 = 470k
alter rbc2 = 470k
alter cksm = 0.1p
alter cks1 = 0.1p
alter cks2 = 0.1p
alter ccavm = 1e-18
alter ccav1 = 1e-18
alter ccav2 = 1e-18
print @cksm[capacitance] @cks1[capacitance] @cks2[capacitance] @ccavm[capacitance] @ccav1[capacitance] @ccav2[capacitance]
tran 1e-05 19.0 0 1e-05
wrdata tm0x12_lz_iii$d v(mainjack) v(fixjack1) v(fixjack2)
wrdata tm0x12_lz_iii_stati$d v(xls.xs) v(xlp.xs) v(dep) v(ina) v(vplus) v(vminus) v(main_a) v(mainc) v(fixc1) v(fixc2)
destroy all
echo "tm0x12_lz_iii_i,tm0x12_lz_iii.dat,l29d2_iii,1000,0,t0a12,100k,1.0,8.0,19.0,1e-05,evento,g10sempre_lz_iii,g10mai_lz_iii,6.5,2,A_ins;B2" >> tb_v2_casopeggiore_manifest.csv
echo "tm0x12_lz_iii_c,tm0x12_lz_iii.dat,l29d2_iii,1000,0,t0a12,100k,8.0,10.0,19.0,1e-05,evento,t12sempre_lz_iii,t12mai_lz_iii,0.0,2,A_ins;A_rel;B2" >> tb_v2_casopeggiore_manifest.csv
* ---- L29d2 2: tm12x0_lz_iii ----
alter vamp dc = 0
alter vfrq dc = 1000
alter rldm = 100k
alter rld1 = 100k
alter rld2 = 100k
alter vti dc = 1.0
alter vtr dc = 10.0
alter vtijk dc = 7.5
alter vtrjk dc = 10.0
alter vosa dc = 0
alter vosb dc = 0
alter vosf1 dc = 0
alter vosf2 dc = 0
alter ratth = 1m
alter rattb = 10k
alter rl1 = 845
alter cwire = 100p
alter vk1i dc = 1
alter vk1t dc = 1000.000000
alter vk5i dc = 1
alter vk5t dc = 1000.000000
alter vt1ri dc = 0
alter vt1rt dc = 8.001000
alter vt1si dc = 1
alter vt1st dc = 8.000000
alter vt2ri dc = 0
alter vt2rt dc = 8.001000
alter vt2si dc = 1
alter vt2st dc = 8.000000
alter vtijk dc = 1000.000000
alter vtrjk dc = 2000.000000
alter vksa dc = 7.500000
alter vksb dc = 10.001000
alter vkca dc = 7.501000
alter vkcb dc = 10.000000
alter vtiser dc = -10
alter vtrser dc = 1000
alter rbym = 1e12
alter rby1 = 1e12
alter rby2 = 1e12
alter rbcm = 220k
alter rbc1 = 470k
alter rbc2 = 470k
alter cksm = 0.1p
alter cks1 = 0.1p
alter cks2 = 0.1p
alter ccavm = 1e-18
alter ccav1 = 1e-18
alter ccav2 = 1e-18
print @cksm[capacitance] @cks1[capacitance] @cks2[capacitance] @ccavm[capacitance] @ccav1[capacitance] @ccav2[capacitance]
tran 1e-05 19.0 0 1e-05
wrdata tm12x0_lz_iii$d v(mainjack) v(fixjack1) v(fixjack2)
wrdata tm12x0_lz_iii_stati$d v(xls.xs) v(xlp.xs) v(dep) v(ina) v(vplus) v(vminus) v(main_a) v(mainc) v(fixc1) v(fixc2)
destroy all
echo "tm12x0_lz_iii_i,tm12x0_lz_iii.dat,l29d2_iii,1000,0,t12a0,100k,1.0,8.0,19.0,1e-05,evento,t12sempre_lz_iii,t12mai_lz_iii,6.5,2,A_ins;B2" >> tb_v2_casopeggiore_manifest.csv
echo "tm12x0_lz_iii_c,tm12x0_lz_iii.dat,l29d2_iii,1000,0,t12a0,100k,8.0,10.0,19.0,1e-05,evento,g10sempre_lz_iii,g10mai_lz_iii,0.0,2,A_ins;A_rel;B2" >> tb_v2_casopeggiore_manifest.csv
* ---- L29d2 3: dispersione dpamax_iii ----
alter vamp dc = 0
alter vfrq dc = 1000
alter rldm = 100k
alter rld1 = 100k
alter rld2 = 100k
alter vti dc = 1000
alter vtr dc = 2000
alter vtijk dc = 1000
alter vtrjk dc = 2000
alter vosa dc = 20m
alter vosb dc = 20m
alter vosf1 dc = 20m
alter vosf2 dc = -20m
alter ratth = 1m
alter rattb = 10k
alter rl1 = 845
alter cwire = 100p
alter vk1i dc = 1
alter vk1t dc = 1000.000000
alter vk5i dc = 1
alter vk5t dc = 1000.000000
alter vt1ri dc = 1
alter vt1rt dc = 1000.000000
alter vt1si dc = 0
alter vt1st dc = 1000.000000
alter vt2ri dc = 1
alter vt2rt dc = 1000.000000
alter vt2si dc = 0
alter vt2st dc = 1000.000000
alter vtijk dc = 1000.000000
alter vtrjk dc = 2000.000000
alter vksa dc = 1000.000000
alter vksb dc = 2000.001000
alter vkca dc = 1000.001000
alter vkcb dc = 2000.000000
alter vtiser dc = -10
alter vtrser dc = 1000
alter rbym = 1e12
alter rby1 = 1e12
alter rby2 = 1e12
alter rbcm = 220k
alter rbc1 = 470k
alter rbc2 = 470k
alter cksm = 0.1p
alter cks1 = 0.1p
alter cks2 = 0.1p
alter ccavm = 1e-18
alter ccav1 = 1e-18
alter ccav2 = 1e-18
print @cksm[capacitance] @cks1[capacitance] @cks2[capacitance] @ccavm[capacitance] @ccav1[capacitance] @ccav2[capacitance]
tran 1e-05 19.0 0 1e-05
wrdata rmai_g10t0_dpamax_iii$d v(mainjack) v(fixjack1) v(fixjack2)
wrdata rmai_g10t0_dpamax_iii_stati$d v(xls.xs) v(xlp.xs) v(dep) v(ina) v(vplus) v(vminus) v(main_a) v(mainc) v(fixc1) v(fixc2)
destroy all
echo "rmai_g10t0_dpamax_iii,rmai_g10t0_dpamax_iii.dat,rif_dpamax,1000,0,10,100k,1.0,8.5,19.0,1e-05,rif_mai,-,-,0.0,3," >> tb_v2_casopeggiore_manifest.csv
alter vamp dc = 0
alter vfrq dc = 1000
alter rldm = 100k
alter rld1 = 100k
alter rld2 = 100k
alter vti dc = -10
alter vtr dc = 1000
alter vtijk dc = -10
alter vtrjk dc = 1000
alter vosa dc = 20m
alter vosb dc = 20m
alter vosf1 dc = 20m
alter vosf2 dc = -20m
alter ratth = 1m
alter rattb = 10k
alter rl1 = 845
alter cwire = 100p
alter vk1i dc = 1
alter vk1t dc = 1000.000000
alter vk5i dc = 1
alter vk5t dc = 1000.000000
alter vt1ri dc = 1
alter vt1rt dc = 1000.000000
alter vt1si dc = 0
alter vt1st dc = 1000.000000
alter vt2ri dc = 1
alter vt2rt dc = 1000.000000
alter vt2si dc = 0
alter vt2st dc = 1000.000000
alter vtijk dc = 1000.000000
alter vtrjk dc = 2000.000000
alter vksa dc = -10.000000
alter vksb dc = 1000.001000
alter vkca dc = -9.999000
alter vkcb dc = 1000.000000
alter vtiser dc = -10
alter vtrser dc = 1000
alter rbym = 1e12
alter rby1 = 1e12
alter rby2 = 1e12
alter rbcm = 220k
alter rbc1 = 470k
alter rbc2 = 470k
alter cksm = 0.1p
alter cks1 = 0.1p
alter cks2 = 0.1p
alter ccavm = 1e-18
alter ccav1 = 1e-18
alter ccav2 = 1e-18
print @cksm[capacitance] @cks1[capacitance] @cks2[capacitance] @ccavm[capacitance] @ccav1[capacitance] @ccav2[capacitance]
tran 1e-05 19.0 0 1e-05
wrdata rsempre_g10t0_dpamax_iii$d v(mainjack) v(fixjack1) v(fixjack2)
wrdata rsempre_g10t0_dpamax_iii_stati$d v(xls.xs) v(xlp.xs) v(dep) v(ina) v(vplus) v(vminus) v(main_a) v(mainc) v(fixc1) v(fixc2)
destroy all
echo "rsempre_g10t0_dpamax_iii,rsempre_g10t0_dpamax_iii.dat,rif_dpamax,1000,0,10,100k,1.0,8.5,19.0,1e-05,rif_sempre,-,-,0.0,3," >> tb_v2_casopeggiore_manifest.csv
alter vamp dc = 0
alter vfrq dc = 1000
alter rldm = 100k
alter rld1 = 100k
alter rld2 = 100k
alter vti dc = 1000
alter vtr dc = 2000
alter vtijk dc = 1000
alter vtrjk dc = 2000
alter vosa dc = 20m
alter vosb dc = 20m
alter vosf1 dc = 20m
alter vosf2 dc = -20m
alter ratth = 1m
alter rattb = 10k
alter rl1 = 845
alter cwire = 100p
alter vk1i dc = 0
alter vk1t dc = 1000.000000
alter vk5i dc = 0
alter vk5t dc = 1000.000000
alter vt1ri dc = 1
alter vt1rt dc = 1000.000000
alter vt1si dc = 0
alter vt1st dc = 1000.000000
alter vt2ri dc = 1
alter vt2rt dc = 1000.000000
alter vt2si dc = 0
alter vt2st dc = 1000.000000
alter vtijk dc = 1000.000000
alter vtrjk dc = 2000.000000
alter vksa dc = 1000.000000
alter vksb dc = 2000.001000
alter vkca dc = 1000.001000
alter vkcb dc = 2000.000000
alter vtiser dc = -10
alter vtrser dc = 1000
alter rbym = 1e12
alter rby1 = 1e12
alter rby2 = 1e12
alter rbcm = 220k
alter rbc1 = 470k
alter rbc2 = 470k
alter cksm = 0.1p
alter cks1 = 0.1p
alter cks2 = 0.1p
alter ccavm = 1e-18
alter ccav1 = 1e-18
alter ccav2 = 1e-18
print @cksm[capacitance] @cks1[capacitance] @cks2[capacitance] @ccavm[capacitance] @ccav1[capacitance] @ccav2[capacitance]
tran 1e-05 19.0 0 1e-05
wrdata rmai_g0t0_dpamax_iii$d v(mainjack) v(fixjack1) v(fixjack2)
wrdata rmai_g0t0_dpamax_iii_stati$d v(xls.xs) v(xlp.xs) v(dep) v(ina) v(vplus) v(vminus) v(main_a) v(mainc) v(fixc1) v(fixc2)
destroy all
echo "rmai_g0t0_dpamax_iii,rmai_g0t0_dpamax_iii.dat,rif_dpamax,1000,0,0,100k,1.0,8.5,19.0,1e-05,rif_mai,-,-,0.0,3," >> tb_v2_casopeggiore_manifest.csv
alter vamp dc = 0
alter vfrq dc = 1000
alter rldm = 100k
alter rld1 = 100k
alter rld2 = 100k
alter vti dc = -10
alter vtr dc = 1000
alter vtijk dc = -10
alter vtrjk dc = 1000
alter vosa dc = 20m
alter vosb dc = 20m
alter vosf1 dc = 20m
alter vosf2 dc = -20m
alter ratth = 1m
alter rattb = 10k
alter rl1 = 845
alter cwire = 100p
alter vk1i dc = 0
alter vk1t dc = 1000.000000
alter vk5i dc = 0
alter vk5t dc = 1000.000000
alter vt1ri dc = 1
alter vt1rt dc = 1000.000000
alter vt1si dc = 0
alter vt1st dc = 1000.000000
alter vt2ri dc = 1
alter vt2rt dc = 1000.000000
alter vt2si dc = 0
alter vt2st dc = 1000.000000
alter vtijk dc = 1000.000000
alter vtrjk dc = 2000.000000
alter vksa dc = -10.000000
alter vksb dc = 1000.001000
alter vkca dc = -9.999000
alter vkcb dc = 1000.000000
alter vtiser dc = -10
alter vtrser dc = 1000
alter rbym = 1e12
alter rby1 = 1e12
alter rby2 = 1e12
alter rbcm = 220k
alter rbc1 = 470k
alter rbc2 = 470k
alter cksm = 0.1p
alter cks1 = 0.1p
alter cks2 = 0.1p
alter ccavm = 1e-18
alter ccav1 = 1e-18
alter ccav2 = 1e-18
print @cksm[capacitance] @cks1[capacitance] @cks2[capacitance] @ccavm[capacitance] @ccav1[capacitance] @ccav2[capacitance]
tran 1e-05 19.0 0 1e-05
wrdata rsempre_g0t0_dpamax_iii$d v(mainjack) v(fixjack1) v(fixjack2)
wrdata rsempre_g0t0_dpamax_iii_stati$d v(xls.xs) v(xlp.xs) v(dep) v(ina) v(vplus) v(vminus) v(main_a) v(mainc) v(fixc1) v(fixc2)
destroy all
echo "rsempre_g0t0_dpamax_iii,rsempre_g0t0_dpamax_iii.dat,rif_dpamax,1000,0,0,100k,1.0,8.5,19.0,1e-05,rif_sempre,-,-,0.0,3," >> tb_v2_casopeggiore_manifest.csv
alter vamp dc = 0
alter vfrq dc = 1000
alter rldm = 100k
alter rld1 = 100k
alter rld2 = 100k
alter vti dc = 1000
alter vtr dc = 2000
alter vtijk dc = 1000
alter vtrjk dc = 2000
alter vosa dc = 20m
alter vosb dc = 20m
alter vosf1 dc = 20m
alter vosf2 dc = -20m
alter ratth = 1m
alter rattb = 10k
alter rl1 = 845
alter cwire = 100p
alter vk1i dc = 1
alter vk1t dc = 1000.000000
alter vk5i dc = 1
alter vk5t dc = 1000.000000
alter vt1ri dc = 0
alter vt1rt dc = 1000.000000
alter vt1si dc = 1
alter vt1st dc = 1000.000000
alter vt2ri dc = 0
alter vt2rt dc = 1000.000000
alter vt2si dc = 1
alter vt2st dc = 1000.000000
alter vtijk dc = 1000.000000
alter vtrjk dc = 2000.000000
alter vksa dc = 1000.000000
alter vksb dc = 2000.001000
alter vkca dc = 1000.001000
alter vkcb dc = 2000.000000
alter vtiser dc = -10
alter vtrser dc = 1000
alter rbym = 1e12
alter rby1 = 1e12
alter rby2 = 1e12
alter rbcm = 220k
alter rbc1 = 470k
alter rbc2 = 470k
alter cksm = 0.1p
alter cks1 = 0.1p
alter cks2 = 0.1p
alter ccavm = 1e-18
alter ccav1 = 1e-18
alter ccav2 = 1e-18
print @cksm[capacitance] @cks1[capacitance] @cks2[capacitance] @ccavm[capacitance] @ccav1[capacitance] @ccav2[capacitance]
tran 1e-05 19.0 0 1e-05
wrdata rmai_g10t12_dpamax_iii$d v(mainjack) v(fixjack1) v(fixjack2)
wrdata rmai_g10t12_dpamax_iii_stati$d v(xls.xs) v(xlp.xs) v(dep) v(ina) v(vplus) v(vminus) v(main_a) v(mainc) v(fixc1) v(fixc2)
destroy all
echo "rmai_g10t12_dpamax_iii,rmai_g10t12_dpamax_iii.dat,rif_dpamax,1000,0,10,100k,1.0,8.5,19.0,1e-05,rif_mai,-,-,0.0,3," >> tb_v2_casopeggiore_manifest.csv
alter vamp dc = 0
alter vfrq dc = 1000
alter rldm = 100k
alter rld1 = 100k
alter rld2 = 100k
alter vti dc = -10
alter vtr dc = 1000
alter vtijk dc = -10
alter vtrjk dc = 1000
alter vosa dc = 20m
alter vosb dc = 20m
alter vosf1 dc = 20m
alter vosf2 dc = -20m
alter ratth = 1m
alter rattb = 10k
alter rl1 = 845
alter cwire = 100p
alter vk1i dc = 1
alter vk1t dc = 1000.000000
alter vk5i dc = 1
alter vk5t dc = 1000.000000
alter vt1ri dc = 0
alter vt1rt dc = 1000.000000
alter vt1si dc = 1
alter vt1st dc = 1000.000000
alter vt2ri dc = 0
alter vt2rt dc = 1000.000000
alter vt2si dc = 1
alter vt2st dc = 1000.000000
alter vtijk dc = 1000.000000
alter vtrjk dc = 2000.000000
alter vksa dc = -10.000000
alter vksb dc = 1000.001000
alter vkca dc = -9.999000
alter vkcb dc = 1000.000000
alter vtiser dc = -10
alter vtrser dc = 1000
alter rbym = 1e12
alter rby1 = 1e12
alter rby2 = 1e12
alter rbcm = 220k
alter rbc1 = 470k
alter rbc2 = 470k
alter cksm = 0.1p
alter cks1 = 0.1p
alter cks2 = 0.1p
alter ccavm = 1e-18
alter ccav1 = 1e-18
alter ccav2 = 1e-18
print @cksm[capacitance] @cks1[capacitance] @cks2[capacitance] @ccavm[capacitance] @ccav1[capacitance] @ccav2[capacitance]
tran 1e-05 19.0 0 1e-05
wrdata rsempre_g10t12_dpamax_iii$d v(mainjack) v(fixjack1) v(fixjack2)
wrdata rsempre_g10t12_dpamax_iii_stati$d v(xls.xs) v(xlp.xs) v(dep) v(ina) v(vplus) v(vminus) v(main_a) v(mainc) v(fixc1) v(fixc2)
destroy all
echo "rsempre_g10t12_dpamax_iii,rsempre_g10t12_dpamax_iii.dat,rif_dpamax,1000,0,10,100k,1.0,8.5,19.0,1e-05,rif_sempre,-,-,0.0,3," >> tb_v2_casopeggiore_manifest.csv
alter vamp dc = 0
alter vfrq dc = 1000
alter rldm = 100k
alter rld1 = 100k
alter rld2 = 100k
alter vti dc = 1.0
alter vtr dc = 10.0
alter vtijk dc = 7.5
alter vtrjk dc = 10.0
alter vosa dc = 20m
alter vosb dc = 20m
alter vosf1 dc = 20m
alter vosf2 dc = -20m
alter ratth = 1m
alter rattb = 10k
alter rl1 = 845
alter cwire = 100p
alter vk1i dc = 0
alter vk1t dc = 8.000300
alter vk5i dc = 0
alter vk5t dc = 8.000000
alter vt1ri dc = 1
alter vt1rt dc = 1000.000000
alter vt1si dc = 0
alter vt1st dc = 1000.000000
alter vt2ri dc = 1
alter vt2rt dc = 1000.000000
alter vt2si dc = 0
alter vt2st dc = 1000.000000
alter vtijk dc = 1000.000000
alter vtrjk dc = 2000.000000
alter vksa dc = 7.500000
alter vksb dc = 10.001000
alter vkca dc = 7.501000
alter vkcb dc = 10.000000
alter vtiser dc = -10
alter vtrser dc = 1000
alter rbym = 1e12
alter rby1 = 1e12
alter rby2 = 1e12
alter rbcm = 220k
alter rbc1 = 470k
alter rbc2 = 470k
alter cksm = 0.1p
alter cks1 = 0.1p
alter cks2 = 0.1p
alter ccavm = 1e-18
alter ccav1 = 1e-18
alter ccav2 = 1e-18
print @cksm[capacitance] @cks1[capacitance] @cks2[capacitance] @ccavm[capacitance] @ccav1[capacitance] @ccav2[capacitance]
tran 1e-05 19.0 0 1e-05
wrdata x01000_dpamax_iii$d v(mainjack) v(fixjack1) v(fixjack2)
wrdata x01000_dpamax_iii_stati$d v(xls.xs) v(xlp.xs) v(dep) v(ina) v(vplus) v(vminus) v(main_a) v(mainc) v(fixc1) v(fixc2)
destroy all
echo "x01000_dpamax_iii_i,x01000_dpamax_iii.dat,l29d2_iii_dpamax,1000,0,g0a10_t0a0,100k,1.0,8.0,19.0,1e-05,evento,rsempre_g0t0_dpamax_iii,rmai_g0t0_dpamax_iii,6.5,3,A_ins;B2" >> tb_v2_casopeggiore_manifest.csv
echo "x01000_dpamax_iii_c,x01000_dpamax_iii.dat,l29d2_iii_dpamax,1000,0,g0a10_t0a0,100k,8.0,10.0,19.0,1e-05,evento,rsempre_g10t0_dpamax_iii,rmai_g10t0_dpamax_iii,0.0,3,A_ins;A_rel;B2" >> tb_v2_casopeggiore_manifest.csv
alter vamp dc = 0
alter vfrq dc = 1000
alter rldm = 100k
alter rld1 = 100k
alter rld2 = 100k
alter vti dc = 1.0
alter vtr dc = 10.0
alter vtijk dc = 7.5
alter vtrjk dc = 10.0
alter vosa dc = 20m
alter vosb dc = 20m
alter vosf1 dc = 20m
alter vosf2 dc = -20m
alter ratth = 1m
alter rattb = 10k
alter rl1 = 845
alter cwire = 100p
alter vk1i dc = 1
alter vk1t dc = 8.000000
alter vk5i dc = 1
alter vk5t dc = 8.000300
alter vt1ri dc = 1
alter vt1rt dc = 1000.000000
alter vt1si dc = 0
alter vt1st dc = 1000.000000
alter vt2ri dc = 1
alter vt2rt dc = 1000.000000
alter vt2si dc = 0
alter vt2st dc = 1000.000000
alter vtijk dc = 1000.000000
alter vtrjk dc = 2000.000000
alter vksa dc = 7.500000
alter vksb dc = 10.001000
alter vkca dc = 7.501000
alter vkcb dc = 10.000000
alter vtiser dc = -10
alter vtrser dc = 1000
alter rbym = 1e12
alter rby1 = 1e12
alter rby2 = 1e12
alter rbcm = 220k
alter rbc1 = 470k
alter rbc2 = 470k
alter cksm = 0.1p
alter cks1 = 0.1p
alter cks2 = 0.1p
alter ccavm = 1e-18
alter ccav1 = 1e-18
alter ccav2 = 1e-18
print @cksm[capacitance] @cks1[capacitance] @cks2[capacitance] @ccavm[capacitance] @ccav1[capacitance] @ccav2[capacitance]
tran 1e-05 19.0 0 1e-05
wrdata x10000_dpamax_iii$d v(mainjack) v(fixjack1) v(fixjack2)
wrdata x10000_dpamax_iii_stati$d v(xls.xs) v(xlp.xs) v(dep) v(ina) v(vplus) v(vminus) v(main_a) v(mainc) v(fixc1) v(fixc2)
destroy all
echo "x10000_dpamax_iii_i,x10000_dpamax_iii.dat,l29d2_iii_dpamax,1000,0,g10a0_t0a0,100k,1.0,8.0,19.0,1e-05,evento,rsempre_g10t0_dpamax_iii,rmai_g10t0_dpamax_iii,6.5,3,A_ins;B2" >> tb_v2_casopeggiore_manifest.csv
echo "x10000_dpamax_iii_c,x10000_dpamax_iii.dat,l29d2_iii_dpamax,1000,0,g10a0_t0a0,100k,8.0,10.0,19.0,1e-05,evento,rsempre_g0t0_dpamax_iii,rmai_g0t0_dpamax_iii,0.0,3,A_ins;A_rel;B2" >> tb_v2_casopeggiore_manifest.csv
alter vamp dc = 0
alter vfrq dc = 1000
alter rldm = 100k
alter rld1 = 100k
alter rld2 = 100k
alter vti dc = 1.0
alter vtr dc = 10.0
alter vtijk dc = 7.5
alter vtrjk dc = 10.0
alter vosa dc = 20m
alter vosb dc = 20m
alter vosf1 dc = 20m
alter vosf2 dc = -20m
alter ratth = 1m
alter rattb = 10k
alter rl1 = 845
alter cwire = 100p
alter vk1i dc = 1
alter vk1t dc = 1000.000000
alter vk5i dc = 1
alter vk5t dc = 1000.000000
alter vt1ri dc = 1
alter vt1rt dc = 8.000000
alter vt1si dc = 0
alter vt1st dc = 8.001000
alter vt2ri dc = 1
alter vt2rt dc = 8.000000
alter vt2si dc = 0
alter vt2st dc = 8.001000
alter vtijk dc = 1000.000000
alter vtrjk dc = 2000.000000
alter vksa dc = 7.500000
alter vksb dc = 10.001000
alter vkca dc = 7.501000
alter vkcb dc = 10.000000
alter vtiser dc = -10
alter vtrser dc = 1000
alter rbym = 1e12
alter rby1 = 1e12
alter rby2 = 1e12
alter rbcm = 220k
alter rbc1 = 470k
alter rbc2 = 470k
alter cksm = 0.1p
alter cks1 = 0.1p
alter cks2 = 0.1p
alter ccavm = 1e-18
alter ccav1 = 1e-18
alter ccav2 = 1e-18
print @cksm[capacitance] @cks1[capacitance] @cks2[capacitance] @ccavm[capacitance] @ccav1[capacitance] @ccav2[capacitance]
tran 1e-05 19.0 0 1e-05
wrdata x1010012_dpamax_iii$d v(mainjack) v(fixjack1) v(fixjack2)
wrdata x1010012_dpamax_iii_stati$d v(xls.xs) v(xlp.xs) v(dep) v(ina) v(vplus) v(vminus) v(main_a) v(mainc) v(fixc1) v(fixc2)
destroy all
echo "x1010012_dpamax_iii_i,x1010012_dpamax_iii.dat,l29d2_iii_dpamax,1000,0,g10a10_t0a12,100k,1.0,8.0,19.0,1e-05,evento,rsempre_g10t0_dpamax_iii,rmai_g10t0_dpamax_iii,6.5,3,A_ins;B2" >> tb_v2_casopeggiore_manifest.csv
echo "x1010012_dpamax_iii_c,x1010012_dpamax_iii.dat,l29d2_iii_dpamax,1000,0,g10a10_t0a12,100k,8.0,10.0,19.0,1e-05,evento,rsempre_g10t12_dpamax_iii,rmai_g10t12_dpamax_iii,0.0,3,A_ins;A_rel;B2" >> tb_v2_casopeggiore_manifest.csv
alter vamp dc = 0
alter vfrq dc = 1000
alter rldm = 100k
alter rld1 = 100k
alter rld2 = 100k
alter vti dc = 1.0
alter vtr dc = 10.0
alter vtijk dc = 7.5
alter vtrjk dc = 10.0
alter vosa dc = 20m
alter vosb dc = 20m
alter vosf1 dc = 20m
alter vosf2 dc = -20m
alter ratth = 1m
alter rattb = 10k
alter rl1 = 845
alter cwire = 100p
alter vk1i dc = 1
alter vk1t dc = 1000.000000
alter vk5i dc = 1
alter vk5t dc = 1000.000000
alter vt1ri dc = 0
alter vt1rt dc = 8.001000
alter vt1si dc = 1
alter vt1st dc = 8.000000
alter vt2ri dc = 0
alter vt2rt dc = 8.001000
alter vt2si dc = 1
alter vt2st dc = 8.000000
alter vtijk dc = 1000.000000
alter vtrjk dc = 2000.000000
alter vksa dc = 7.500000
alter vksb dc = 10.001000
alter vkca dc = 7.501000
alter vkcb dc = 10.000000
alter vtiser dc = -10
alter vtrser dc = 1000
alter rbym = 1e12
alter rby1 = 1e12
alter rby2 = 1e12
alter rbcm = 220k
alter rbc1 = 470k
alter rbc2 = 470k
alter cksm = 0.1p
alter cks1 = 0.1p
alter cks2 = 0.1p
alter ccavm = 1e-18
alter ccav1 = 1e-18
alter ccav2 = 1e-18
print @cksm[capacitance] @cks1[capacitance] @cks2[capacitance] @ccavm[capacitance] @ccav1[capacitance] @ccav2[capacitance]
tran 1e-05 19.0 0 1e-05
wrdata x1010120_dpamax_iii$d v(mainjack) v(fixjack1) v(fixjack2)
wrdata x1010120_dpamax_iii_stati$d v(xls.xs) v(xlp.xs) v(dep) v(ina) v(vplus) v(vminus) v(main_a) v(mainc) v(fixc1) v(fixc2)
destroy all
echo "x1010120_dpamax_iii_i,x1010120_dpamax_iii.dat,l29d2_iii_dpamax,1000,0,g10a10_t12a0,100k,1.0,8.0,19.0,1e-05,evento,rsempre_g10t12_dpamax_iii,rmai_g10t12_dpamax_iii,6.5,3,A_ins;B2" >> tb_v2_casopeggiore_manifest.csv
echo "x1010120_dpamax_iii_c,x1010120_dpamax_iii.dat,l29d2_iii_dpamax,1000,0,g10a10_t12a0,100k,8.0,10.0,19.0,1e-05,evento,rsempre_g10t0_dpamax_iii,rmai_g10t0_dpamax_iii,0.0,3,A_ins;A_rel;B2" >> tb_v2_casopeggiore_manifest.csv
alter vamp dc = 0
alter vfrq dc = 1000
alter rldm = 100k
alter rld1 = 100k
alter rld2 = 100k
alter vti dc = 1.0
alter vtr dc = 8.5
alter vtijk dc = 7.5
alter vtrjk dc = 8.5
alter vosa dc = 20m
alter vosb dc = 20m
alter vosf1 dc = 20m
alter vosf2 dc = -20m
alter ratth = 1m
alter rattb = 10k
alter rl1 = 845
alter cwire = 100p
alter vk1i dc = 1
alter vk1t dc = 1000.000000
alter vk5i dc = 1
alter vk5t dc = 1000.000000
alter vt1ri dc = 1
alter vt1rt dc = 1000.000000
alter vt1si dc = 0
alter vt1st dc = 1000.000000
alter vt2ri dc = 1
alter vt2rt dc = 1000.000000
alter vt2si dc = 0
alter vt2st dc = 1000.000000
alter vtijk dc = 1000.000000
alter vtrjk dc = 2000.000000
alter vksa dc = 7.500000
alter vksb dc = 8.501000
alter vkca dc = 7.501000
alter vkcb dc = 8.500000
alter vtiser dc = -10
alter vtrser dc = 1000
alter rbym = 1e12
alter rby1 = 1e12
alter rby2 = 1e12
alter rbcm = 220k
alter rbc1 = 470k
alter rbc2 = 470k
alter cksm = 0.1p
alter cks1 = 0.1p
alter cks2 = 0.1p
alter ccavm = 1e-18
alter ccav1 = 1e-18
alter ccav2 = 1e-18
print @cksm[capacitance] @cks1[capacitance] @cks2[capacitance] @ccavm[capacitance] @ccav1[capacitance] @ccav2[capacitance]
tran 1e-05 17.5 0 1e-05
wrdata xm_dpamax_iii$d v(mainjack) v(fixjack1) v(fixjack2)
wrdata xm_dpamax_iii_stati$d v(xls.xs) v(xlp.xs) v(dep) v(ina) v(vplus) v(vminus) v(main_a) v(mainc) v(fixc1) v(fixc2)
destroy all
echo "xm_dpamax_iii,xm_dpamax_iii.dat,l29d2_iii_dpamax,1000,0,10,100k,1.0,8.5,17.5,1e-05,evento,rsempre_g10t0_dpamax_iii,rmai_g10t0_dpamax_iii,6.5,3,A_ins;A_rel;B2" >> tb_v2_casopeggiore_manifest.csv
* ---- L29d2 3: dispersione dpminmax_iii ----
alter vamp dc = 0
alter vfrq dc = 1000
alter rldm = 100k
alter rld1 = 100k
alter rld2 = 100k
alter vti dc = 1000
alter vtr dc = 2000
alter vtijk dc = 1000
alter vtrjk dc = 2000
alter vosa dc = 20m
alter vosb dc = 20m
alter vosf1 dc = 20m
alter vosf2 dc = -20m
alter ratth = 1m
alter rattb = 10k
alter rl1 = 845
alter cwire = 100p
alter vk1i dc = 1
alter vk1t dc = 1000.000000
alter vk5i dc = 1
alter vk5t dc = 1000.000000
alter vt1ri dc = 1
alter vt1rt dc = 1000.000000
alter vt1si dc = 0
alter vt1st dc = 1000.000000
alter vt2ri dc = 1
alter vt2rt dc = 1000.000000
alter vt2si dc = 0
alter vt2st dc = 1000.000000
alter vtijk dc = 1000.000000
alter vtrjk dc = 2000.000000
alter vksa dc = 1000.000000
alter vksb dc = 2000.001000
alter vkca dc = 1000.001000
alter vkcb dc = 2000.000000
alter vtiser dc = -10
alter vtrser dc = 1000
alter rbym = 1e12
alter rby1 = 1e12
alter rby2 = 1e12
alter rbcm = 220k
alter rbc1 = 470k
alter rbc2 = 470k
alter cksm = 0.1p
alter cks1 = 0.1p
alter cks2 = 0.1p
alter ccavm = 1e-18
alter ccav1 = 1e-18
alter ccav2 = 1e-18
print @cksm[capacitance] @cks1[capacitance] @cks2[capacitance] @ccavm[capacitance] @ccav1[capacitance] @ccav2[capacitance]
altermod lsk489a vto = -2.086
showmod jprb : vto beta
op
tran 1e-05 19.0 0 1e-05
wrdata rmai_g10t0_dpminmax_iii$d v(mainjack) v(fixjack1) v(fixjack2)
wrdata rmai_g10t0_dpminmax_iii_stati$d v(xls.xs) v(xlp.xs) v(dep) v(ina) v(vplus) v(vminus) v(main_a) v(mainc) v(fixc1) v(fixc2)
destroy all
echo "rmai_g10t0_dpminmax_iii,rmai_g10t0_dpminmax_iii.dat,rif_dpminmax,1000,0,10,100k,1.0,8.5,19.0,1e-05,rif_mai,-,-,0.0,3," >> tb_v2_casopeggiore_manifest.csv
alter vamp dc = 0
alter vfrq dc = 1000
alter rldm = 100k
alter rld1 = 100k
alter rld2 = 100k
alter vti dc = -10
alter vtr dc = 1000
alter vtijk dc = -10
alter vtrjk dc = 1000
alter vosa dc = 20m
alter vosb dc = 20m
alter vosf1 dc = 20m
alter vosf2 dc = -20m
alter ratth = 1m
alter rattb = 10k
alter rl1 = 845
alter cwire = 100p
alter vk1i dc = 1
alter vk1t dc = 1000.000000
alter vk5i dc = 1
alter vk5t dc = 1000.000000
alter vt1ri dc = 1
alter vt1rt dc = 1000.000000
alter vt1si dc = 0
alter vt1st dc = 1000.000000
alter vt2ri dc = 1
alter vt2rt dc = 1000.000000
alter vt2si dc = 0
alter vt2st dc = 1000.000000
alter vtijk dc = 1000.000000
alter vtrjk dc = 2000.000000
alter vksa dc = -10.000000
alter vksb dc = 1000.001000
alter vkca dc = -9.999000
alter vkcb dc = 1000.000000
alter vtiser dc = -10
alter vtrser dc = 1000
alter rbym = 1e12
alter rby1 = 1e12
alter rby2 = 1e12
alter rbcm = 220k
alter rbc1 = 470k
alter rbc2 = 470k
alter cksm = 0.1p
alter cks1 = 0.1p
alter cks2 = 0.1p
alter ccavm = 1e-18
alter ccav1 = 1e-18
alter ccav2 = 1e-18
print @cksm[capacitance] @cks1[capacitance] @cks2[capacitance] @ccavm[capacitance] @ccav1[capacitance] @ccav2[capacitance]
altermod lsk489a vto = -2.086
showmod jprb : vto beta
op
tran 1e-05 19.0 0 1e-05
wrdata rsempre_g10t0_dpminmax_iii$d v(mainjack) v(fixjack1) v(fixjack2)
wrdata rsempre_g10t0_dpminmax_iii_stati$d v(xls.xs) v(xlp.xs) v(dep) v(ina) v(vplus) v(vminus) v(main_a) v(mainc) v(fixc1) v(fixc2)
destroy all
echo "rsempre_g10t0_dpminmax_iii,rsempre_g10t0_dpminmax_iii.dat,rif_dpminmax,1000,0,10,100k,1.0,8.5,19.0,1e-05,rif_sempre,-,-,0.0,3," >> tb_v2_casopeggiore_manifest.csv
alter vamp dc = 0
alter vfrq dc = 1000
alter rldm = 100k
alter rld1 = 100k
alter rld2 = 100k
alter vti dc = 1000
alter vtr dc = 2000
alter vtijk dc = 1000
alter vtrjk dc = 2000
alter vosa dc = 20m
alter vosb dc = 20m
alter vosf1 dc = 20m
alter vosf2 dc = -20m
alter ratth = 1m
alter rattb = 10k
alter rl1 = 845
alter cwire = 100p
alter vk1i dc = 0
alter vk1t dc = 1000.000000
alter vk5i dc = 0
alter vk5t dc = 1000.000000
alter vt1ri dc = 1
alter vt1rt dc = 1000.000000
alter vt1si dc = 0
alter vt1st dc = 1000.000000
alter vt2ri dc = 1
alter vt2rt dc = 1000.000000
alter vt2si dc = 0
alter vt2st dc = 1000.000000
alter vtijk dc = 1000.000000
alter vtrjk dc = 2000.000000
alter vksa dc = 1000.000000
alter vksb dc = 2000.001000
alter vkca dc = 1000.001000
alter vkcb dc = 2000.000000
alter vtiser dc = -10
alter vtrser dc = 1000
alter rbym = 1e12
alter rby1 = 1e12
alter rby2 = 1e12
alter rbcm = 220k
alter rbc1 = 470k
alter rbc2 = 470k
alter cksm = 0.1p
alter cks1 = 0.1p
alter cks2 = 0.1p
alter ccavm = 1e-18
alter ccav1 = 1e-18
alter ccav2 = 1e-18
print @cksm[capacitance] @cks1[capacitance] @cks2[capacitance] @ccavm[capacitance] @ccav1[capacitance] @ccav2[capacitance]
altermod lsk489a vto = -2.086
showmod jprb : vto beta
op
tran 1e-05 19.0 0 1e-05
wrdata rmai_g0t0_dpminmax_iii$d v(mainjack) v(fixjack1) v(fixjack2)
wrdata rmai_g0t0_dpminmax_iii_stati$d v(xls.xs) v(xlp.xs) v(dep) v(ina) v(vplus) v(vminus) v(main_a) v(mainc) v(fixc1) v(fixc2)
destroy all
echo "rmai_g0t0_dpminmax_iii,rmai_g0t0_dpminmax_iii.dat,rif_dpminmax,1000,0,0,100k,1.0,8.5,19.0,1e-05,rif_mai,-,-,0.0,3," >> tb_v2_casopeggiore_manifest.csv
alter vamp dc = 0
alter vfrq dc = 1000
alter rldm = 100k
alter rld1 = 100k
alter rld2 = 100k
alter vti dc = -10
alter vtr dc = 1000
alter vtijk dc = -10
alter vtrjk dc = 1000
alter vosa dc = 20m
alter vosb dc = 20m
alter vosf1 dc = 20m
alter vosf2 dc = -20m
alter ratth = 1m
alter rattb = 10k
alter rl1 = 845
alter cwire = 100p
alter vk1i dc = 0
alter vk1t dc = 1000.000000
alter vk5i dc = 0
alter vk5t dc = 1000.000000
alter vt1ri dc = 1
alter vt1rt dc = 1000.000000
alter vt1si dc = 0
alter vt1st dc = 1000.000000
alter vt2ri dc = 1
alter vt2rt dc = 1000.000000
alter vt2si dc = 0
alter vt2st dc = 1000.000000
alter vtijk dc = 1000.000000
alter vtrjk dc = 2000.000000
alter vksa dc = -10.000000
alter vksb dc = 1000.001000
alter vkca dc = -9.999000
alter vkcb dc = 1000.000000
alter vtiser dc = -10
alter vtrser dc = 1000
alter rbym = 1e12
alter rby1 = 1e12
alter rby2 = 1e12
alter rbcm = 220k
alter rbc1 = 470k
alter rbc2 = 470k
alter cksm = 0.1p
alter cks1 = 0.1p
alter cks2 = 0.1p
alter ccavm = 1e-18
alter ccav1 = 1e-18
alter ccav2 = 1e-18
print @cksm[capacitance] @cks1[capacitance] @cks2[capacitance] @ccavm[capacitance] @ccav1[capacitance] @ccav2[capacitance]
altermod lsk489a vto = -2.086
showmod jprb : vto beta
op
tran 1e-05 19.0 0 1e-05
wrdata rsempre_g0t0_dpminmax_iii$d v(mainjack) v(fixjack1) v(fixjack2)
wrdata rsempre_g0t0_dpminmax_iii_stati$d v(xls.xs) v(xlp.xs) v(dep) v(ina) v(vplus) v(vminus) v(main_a) v(mainc) v(fixc1) v(fixc2)
destroy all
echo "rsempre_g0t0_dpminmax_iii,rsempre_g0t0_dpminmax_iii.dat,rif_dpminmax,1000,0,0,100k,1.0,8.5,19.0,1e-05,rif_sempre,-,-,0.0,3," >> tb_v2_casopeggiore_manifest.csv
alter vamp dc = 0
alter vfrq dc = 1000
alter rldm = 100k
alter rld1 = 100k
alter rld2 = 100k
alter vti dc = 1000
alter vtr dc = 2000
alter vtijk dc = 1000
alter vtrjk dc = 2000
alter vosa dc = 20m
alter vosb dc = 20m
alter vosf1 dc = 20m
alter vosf2 dc = -20m
alter ratth = 1m
alter rattb = 10k
alter rl1 = 845
alter cwire = 100p
alter vk1i dc = 1
alter vk1t dc = 1000.000000
alter vk5i dc = 1
alter vk5t dc = 1000.000000
alter vt1ri dc = 0
alter vt1rt dc = 1000.000000
alter vt1si dc = 1
alter vt1st dc = 1000.000000
alter vt2ri dc = 0
alter vt2rt dc = 1000.000000
alter vt2si dc = 1
alter vt2st dc = 1000.000000
alter vtijk dc = 1000.000000
alter vtrjk dc = 2000.000000
alter vksa dc = 1000.000000
alter vksb dc = 2000.001000
alter vkca dc = 1000.001000
alter vkcb dc = 2000.000000
alter vtiser dc = -10
alter vtrser dc = 1000
alter rbym = 1e12
alter rby1 = 1e12
alter rby2 = 1e12
alter rbcm = 220k
alter rbc1 = 470k
alter rbc2 = 470k
alter cksm = 0.1p
alter cks1 = 0.1p
alter cks2 = 0.1p
alter ccavm = 1e-18
alter ccav1 = 1e-18
alter ccav2 = 1e-18
print @cksm[capacitance] @cks1[capacitance] @cks2[capacitance] @ccavm[capacitance] @ccav1[capacitance] @ccav2[capacitance]
altermod lsk489a vto = -2.086
showmod jprb : vto beta
op
tran 1e-05 19.0 0 1e-05
wrdata rmai_g10t12_dpminmax_iii$d v(mainjack) v(fixjack1) v(fixjack2)
wrdata rmai_g10t12_dpminmax_iii_stati$d v(xls.xs) v(xlp.xs) v(dep) v(ina) v(vplus) v(vminus) v(main_a) v(mainc) v(fixc1) v(fixc2)
destroy all
echo "rmai_g10t12_dpminmax_iii,rmai_g10t12_dpminmax_iii.dat,rif_dpminmax,1000,0,10,100k,1.0,8.5,19.0,1e-05,rif_mai,-,-,0.0,3," >> tb_v2_casopeggiore_manifest.csv
alter vamp dc = 0
alter vfrq dc = 1000
alter rldm = 100k
alter rld1 = 100k
alter rld2 = 100k
alter vti dc = -10
alter vtr dc = 1000
alter vtijk dc = -10
alter vtrjk dc = 1000
alter vosa dc = 20m
alter vosb dc = 20m
alter vosf1 dc = 20m
alter vosf2 dc = -20m
alter ratth = 1m
alter rattb = 10k
alter rl1 = 845
alter cwire = 100p
alter vk1i dc = 1
alter vk1t dc = 1000.000000
alter vk5i dc = 1
alter vk5t dc = 1000.000000
alter vt1ri dc = 0
alter vt1rt dc = 1000.000000
alter vt1si dc = 1
alter vt1st dc = 1000.000000
alter vt2ri dc = 0
alter vt2rt dc = 1000.000000
alter vt2si dc = 1
alter vt2st dc = 1000.000000
alter vtijk dc = 1000.000000
alter vtrjk dc = 2000.000000
alter vksa dc = -10.000000
alter vksb dc = 1000.001000
alter vkca dc = -9.999000
alter vkcb dc = 1000.000000
alter vtiser dc = -10
alter vtrser dc = 1000
alter rbym = 1e12
alter rby1 = 1e12
alter rby2 = 1e12
alter rbcm = 220k
alter rbc1 = 470k
alter rbc2 = 470k
alter cksm = 0.1p
alter cks1 = 0.1p
alter cks2 = 0.1p
alter ccavm = 1e-18
alter ccav1 = 1e-18
alter ccav2 = 1e-18
print @cksm[capacitance] @cks1[capacitance] @cks2[capacitance] @ccavm[capacitance] @ccav1[capacitance] @ccav2[capacitance]
altermod lsk489a vto = -2.086
showmod jprb : vto beta
op
tran 1e-05 19.0 0 1e-05
wrdata rsempre_g10t12_dpminmax_iii$d v(mainjack) v(fixjack1) v(fixjack2)
wrdata rsempre_g10t12_dpminmax_iii_stati$d v(xls.xs) v(xlp.xs) v(dep) v(ina) v(vplus) v(vminus) v(main_a) v(mainc) v(fixc1) v(fixc2)
destroy all
echo "rsempre_g10t12_dpminmax_iii,rsempre_g10t12_dpminmax_iii.dat,rif_dpminmax,1000,0,10,100k,1.0,8.5,19.0,1e-05,rif_sempre,-,-,0.0,3," >> tb_v2_casopeggiore_manifest.csv
alter vamp dc = 0
alter vfrq dc = 1000
alter rldm = 100k
alter rld1 = 100k
alter rld2 = 100k
alter vti dc = 1.0
alter vtr dc = 10.0
alter vtijk dc = 7.5
alter vtrjk dc = 10.0
alter vosa dc = 20m
alter vosb dc = 20m
alter vosf1 dc = 20m
alter vosf2 dc = -20m
alter ratth = 1m
alter rattb = 10k
alter rl1 = 845
alter cwire = 100p
alter vk1i dc = 0
alter vk1t dc = 8.000300
alter vk5i dc = 0
alter vk5t dc = 8.000000
alter vt1ri dc = 1
alter vt1rt dc = 1000.000000
alter vt1si dc = 0
alter vt1st dc = 1000.000000
alter vt2ri dc = 1
alter vt2rt dc = 1000.000000
alter vt2si dc = 0
alter vt2st dc = 1000.000000
alter vtijk dc = 1000.000000
alter vtrjk dc = 2000.000000
alter vksa dc = 7.500000
alter vksb dc = 10.001000
alter vkca dc = 7.501000
alter vkcb dc = 10.000000
alter vtiser dc = -10
alter vtrser dc = 1000
alter rbym = 1e12
alter rby1 = 1e12
alter rby2 = 1e12
alter rbcm = 220k
alter rbc1 = 470k
alter rbc2 = 470k
alter cksm = 0.1p
alter cks1 = 0.1p
alter cks2 = 0.1p
alter ccavm = 1e-18
alter ccav1 = 1e-18
alter ccav2 = 1e-18
print @cksm[capacitance] @cks1[capacitance] @cks2[capacitance] @ccavm[capacitance] @ccav1[capacitance] @ccav2[capacitance]
altermod lsk489a vto = -2.086
showmod jprb : vto beta
op
tran 1e-05 19.0 0 1e-05
wrdata x01000_dpminmax_iii$d v(mainjack) v(fixjack1) v(fixjack2)
wrdata x01000_dpminmax_iii_stati$d v(xls.xs) v(xlp.xs) v(dep) v(ina) v(vplus) v(vminus) v(main_a) v(mainc) v(fixc1) v(fixc2)
destroy all
echo "x01000_dpminmax_iii_i,x01000_dpminmax_iii.dat,l29d2_iii_dpminmax,1000,0,g0a10_t0a0,100k,1.0,8.0,19.0,1e-05,evento,rsempre_g0t0_dpminmax_iii,rmai_g0t0_dpminmax_iii,6.5,3,A_ins;B2" >> tb_v2_casopeggiore_manifest.csv
echo "x01000_dpminmax_iii_c,x01000_dpminmax_iii.dat,l29d2_iii_dpminmax,1000,0,g0a10_t0a0,100k,8.0,10.0,19.0,1e-05,evento,rsempre_g10t0_dpminmax_iii,rmai_g10t0_dpminmax_iii,0.0,3,A_ins;A_rel;B2" >> tb_v2_casopeggiore_manifest.csv
alter vamp dc = 0
alter vfrq dc = 1000
alter rldm = 100k
alter rld1 = 100k
alter rld2 = 100k
alter vti dc = 1.0
alter vtr dc = 10.0
alter vtijk dc = 7.5
alter vtrjk dc = 10.0
alter vosa dc = 20m
alter vosb dc = 20m
alter vosf1 dc = 20m
alter vosf2 dc = -20m
alter ratth = 1m
alter rattb = 10k
alter rl1 = 845
alter cwire = 100p
alter vk1i dc = 1
alter vk1t dc = 8.000000
alter vk5i dc = 1
alter vk5t dc = 8.000300
alter vt1ri dc = 1
alter vt1rt dc = 1000.000000
alter vt1si dc = 0
alter vt1st dc = 1000.000000
alter vt2ri dc = 1
alter vt2rt dc = 1000.000000
alter vt2si dc = 0
alter vt2st dc = 1000.000000
alter vtijk dc = 1000.000000
alter vtrjk dc = 2000.000000
alter vksa dc = 7.500000
alter vksb dc = 10.001000
alter vkca dc = 7.501000
alter vkcb dc = 10.000000
alter vtiser dc = -10
alter vtrser dc = 1000
alter rbym = 1e12
alter rby1 = 1e12
alter rby2 = 1e12
alter rbcm = 220k
alter rbc1 = 470k
alter rbc2 = 470k
alter cksm = 0.1p
alter cks1 = 0.1p
alter cks2 = 0.1p
alter ccavm = 1e-18
alter ccav1 = 1e-18
alter ccav2 = 1e-18
print @cksm[capacitance] @cks1[capacitance] @cks2[capacitance] @ccavm[capacitance] @ccav1[capacitance] @ccav2[capacitance]
altermod lsk489a vto = -2.086
showmod jprb : vto beta
op
tran 1e-05 19.0 0 1e-05
wrdata x10000_dpminmax_iii$d v(mainjack) v(fixjack1) v(fixjack2)
wrdata x10000_dpminmax_iii_stati$d v(xls.xs) v(xlp.xs) v(dep) v(ina) v(vplus) v(vminus) v(main_a) v(mainc) v(fixc1) v(fixc2)
destroy all
echo "x10000_dpminmax_iii_i,x10000_dpminmax_iii.dat,l29d2_iii_dpminmax,1000,0,g10a0_t0a0,100k,1.0,8.0,19.0,1e-05,evento,rsempre_g10t0_dpminmax_iii,rmai_g10t0_dpminmax_iii,6.5,3,A_ins;B2" >> tb_v2_casopeggiore_manifest.csv
echo "x10000_dpminmax_iii_c,x10000_dpminmax_iii.dat,l29d2_iii_dpminmax,1000,0,g10a0_t0a0,100k,8.0,10.0,19.0,1e-05,evento,rsempre_g0t0_dpminmax_iii,rmai_g0t0_dpminmax_iii,0.0,3,A_ins;A_rel;B2" >> tb_v2_casopeggiore_manifest.csv
alter vamp dc = 0
alter vfrq dc = 1000
alter rldm = 100k
alter rld1 = 100k
alter rld2 = 100k
alter vti dc = 1.0
alter vtr dc = 10.0
alter vtijk dc = 7.5
alter vtrjk dc = 10.0
alter vosa dc = 20m
alter vosb dc = 20m
alter vosf1 dc = 20m
alter vosf2 dc = -20m
alter ratth = 1m
alter rattb = 10k
alter rl1 = 845
alter cwire = 100p
alter vk1i dc = 1
alter vk1t dc = 1000.000000
alter vk5i dc = 1
alter vk5t dc = 1000.000000
alter vt1ri dc = 1
alter vt1rt dc = 8.000000
alter vt1si dc = 0
alter vt1st dc = 8.001000
alter vt2ri dc = 1
alter vt2rt dc = 8.000000
alter vt2si dc = 0
alter vt2st dc = 8.001000
alter vtijk dc = 1000.000000
alter vtrjk dc = 2000.000000
alter vksa dc = 7.500000
alter vksb dc = 10.001000
alter vkca dc = 7.501000
alter vkcb dc = 10.000000
alter vtiser dc = -10
alter vtrser dc = 1000
alter rbym = 1e12
alter rby1 = 1e12
alter rby2 = 1e12
alter rbcm = 220k
alter rbc1 = 470k
alter rbc2 = 470k
alter cksm = 0.1p
alter cks1 = 0.1p
alter cks2 = 0.1p
alter ccavm = 1e-18
alter ccav1 = 1e-18
alter ccav2 = 1e-18
print @cksm[capacitance] @cks1[capacitance] @cks2[capacitance] @ccavm[capacitance] @ccav1[capacitance] @ccav2[capacitance]
altermod lsk489a vto = -2.086
showmod jprb : vto beta
op
tran 1e-05 19.0 0 1e-05
wrdata x1010012_dpminmax_iii$d v(mainjack) v(fixjack1) v(fixjack2)
wrdata x1010012_dpminmax_iii_stati$d v(xls.xs) v(xlp.xs) v(dep) v(ina) v(vplus) v(vminus) v(main_a) v(mainc) v(fixc1) v(fixc2)
destroy all
echo "x1010012_dpminmax_iii_i,x1010012_dpminmax_iii.dat,l29d2_iii_dpminmax,1000,0,g10a10_t0a12,100k,1.0,8.0,19.0,1e-05,evento,rsempre_g10t0_dpminmax_iii,rmai_g10t0_dpminmax_iii,6.5,3,A_ins;B2" >> tb_v2_casopeggiore_manifest.csv
echo "x1010012_dpminmax_iii_c,x1010012_dpminmax_iii.dat,l29d2_iii_dpminmax,1000,0,g10a10_t0a12,100k,8.0,10.0,19.0,1e-05,evento,rsempre_g10t12_dpminmax_iii,rmai_g10t12_dpminmax_iii,0.0,3,A_ins;A_rel;B2" >> tb_v2_casopeggiore_manifest.csv
alter vamp dc = 0
alter vfrq dc = 1000
alter rldm = 100k
alter rld1 = 100k
alter rld2 = 100k
alter vti dc = 1.0
alter vtr dc = 10.0
alter vtijk dc = 7.5
alter vtrjk dc = 10.0
alter vosa dc = 20m
alter vosb dc = 20m
alter vosf1 dc = 20m
alter vosf2 dc = -20m
alter ratth = 1m
alter rattb = 10k
alter rl1 = 845
alter cwire = 100p
alter vk1i dc = 1
alter vk1t dc = 1000.000000
alter vk5i dc = 1
alter vk5t dc = 1000.000000
alter vt1ri dc = 0
alter vt1rt dc = 8.001000
alter vt1si dc = 1
alter vt1st dc = 8.000000
alter vt2ri dc = 0
alter vt2rt dc = 8.001000
alter vt2si dc = 1
alter vt2st dc = 8.000000
alter vtijk dc = 1000.000000
alter vtrjk dc = 2000.000000
alter vksa dc = 7.500000
alter vksb dc = 10.001000
alter vkca dc = 7.501000
alter vkcb dc = 10.000000
alter vtiser dc = -10
alter vtrser dc = 1000
alter rbym = 1e12
alter rby1 = 1e12
alter rby2 = 1e12
alter rbcm = 220k
alter rbc1 = 470k
alter rbc2 = 470k
alter cksm = 0.1p
alter cks1 = 0.1p
alter cks2 = 0.1p
alter ccavm = 1e-18
alter ccav1 = 1e-18
alter ccav2 = 1e-18
print @cksm[capacitance] @cks1[capacitance] @cks2[capacitance] @ccavm[capacitance] @ccav1[capacitance] @ccav2[capacitance]
altermod lsk489a vto = -2.086
showmod jprb : vto beta
op
tran 1e-05 19.0 0 1e-05
wrdata x1010120_dpminmax_iii$d v(mainjack) v(fixjack1) v(fixjack2)
wrdata x1010120_dpminmax_iii_stati$d v(xls.xs) v(xlp.xs) v(dep) v(ina) v(vplus) v(vminus) v(main_a) v(mainc) v(fixc1) v(fixc2)
destroy all
echo "x1010120_dpminmax_iii_i,x1010120_dpminmax_iii.dat,l29d2_iii_dpminmax,1000,0,g10a10_t12a0,100k,1.0,8.0,19.0,1e-05,evento,rsempre_g10t12_dpminmax_iii,rmai_g10t12_dpminmax_iii,6.5,3,A_ins;B2" >> tb_v2_casopeggiore_manifest.csv
echo "x1010120_dpminmax_iii_c,x1010120_dpminmax_iii.dat,l29d2_iii_dpminmax,1000,0,g10a10_t12a0,100k,8.0,10.0,19.0,1e-05,evento,rsempre_g10t0_dpminmax_iii,rmai_g10t0_dpminmax_iii,0.0,3,A_ins;A_rel;B2" >> tb_v2_casopeggiore_manifest.csv
alter vamp dc = 0
alter vfrq dc = 1000
alter rldm = 100k
alter rld1 = 100k
alter rld2 = 100k
alter vti dc = 1.0
alter vtr dc = 8.5
alter vtijk dc = 7.5
alter vtrjk dc = 8.5
alter vosa dc = 20m
alter vosb dc = 20m
alter vosf1 dc = 20m
alter vosf2 dc = -20m
alter ratth = 1m
alter rattb = 10k
alter rl1 = 845
alter cwire = 100p
alter vk1i dc = 1
alter vk1t dc = 1000.000000
alter vk5i dc = 1
alter vk5t dc = 1000.000000
alter vt1ri dc = 1
alter vt1rt dc = 1000.000000
alter vt1si dc = 0
alter vt1st dc = 1000.000000
alter vt2ri dc = 1
alter vt2rt dc = 1000.000000
alter vt2si dc = 0
alter vt2st dc = 1000.000000
alter vtijk dc = 1000.000000
alter vtrjk dc = 2000.000000
alter vksa dc = 7.500000
alter vksb dc = 8.501000
alter vkca dc = 7.501000
alter vkcb dc = 8.500000
alter vtiser dc = -10
alter vtrser dc = 1000
alter rbym = 1e12
alter rby1 = 1e12
alter rby2 = 1e12
alter rbcm = 220k
alter rbc1 = 470k
alter rbc2 = 470k
alter cksm = 0.1p
alter cks1 = 0.1p
alter cks2 = 0.1p
alter ccavm = 1e-18
alter ccav1 = 1e-18
alter ccav2 = 1e-18
print @cksm[capacitance] @cks1[capacitance] @cks2[capacitance] @ccavm[capacitance] @ccav1[capacitance] @ccav2[capacitance]
altermod lsk489a vto = -2.086
showmod jprb : vto beta
op
tran 1e-05 17.5 0 1e-05
wrdata xm_dpminmax_iii$d v(mainjack) v(fixjack1) v(fixjack2)
wrdata xm_dpminmax_iii_stati$d v(xls.xs) v(xlp.xs) v(dep) v(ina) v(vplus) v(vminus) v(main_a) v(mainc) v(fixc1) v(fixc2)
destroy all
echo "xm_dpminmax_iii,xm_dpminmax_iii.dat,l29d2_iii_dpminmax,1000,0,10,100k,1.0,8.5,17.5,1e-05,evento,rsempre_g10t0_dpminmax_iii,rmai_g10t0_dpminmax_iii,6.5,3,A_ins;A_rel;B2" >> tb_v2_casopeggiore_manifest.csv
* ---- L29d2 3: dispersione dpmaxmax_iii ----
alter vamp dc = 0
alter vfrq dc = 1000
alter rldm = 100k
alter rld1 = 100k
alter rld2 = 100k
alter vti dc = 1000
alter vtr dc = 2000
alter vtijk dc = 1000
alter vtrjk dc = 2000
alter vosa dc = 20m
alter vosb dc = 20m
alter vosf1 dc = 20m
alter vosf2 dc = -20m
alter ratth = 1m
alter rattb = 10k
alter rl1 = 845
alter cwire = 100p
alter vk1i dc = 1
alter vk1t dc = 1000.000000
alter vk5i dc = 1
alter vk5t dc = 1000.000000
alter vt1ri dc = 1
alter vt1rt dc = 1000.000000
alter vt1si dc = 0
alter vt1st dc = 1000.000000
alter vt2ri dc = 1
alter vt2rt dc = 1000.000000
alter vt2si dc = 0
alter vt2st dc = 1000.000000
alter vtijk dc = 1000.000000
alter vtrjk dc = 2000.000000
alter vksa dc = 1000.000000
alter vksb dc = 2000.001000
alter vkca dc = 1000.001000
alter vkcb dc = 2000.000000
alter vtiser dc = -10
alter vtrser dc = 1000
alter rbym = 1e12
alter rby1 = 1e12
alter rby2 = 1e12
alter rbcm = 220k
alter rbc1 = 470k
alter rbc2 = 470k
alter cksm = 0.1p
alter cks1 = 0.1p
alter cks2 = 0.1p
alter ccavm = 1e-18
alter ccav1 = 1e-18
alter ccav2 = 1e-18
print @cksm[capacitance] @cks1[capacitance] @cks2[capacitance] @ccavm[capacitance] @ccav1[capacitance] @ccav2[capacitance]
altermod lsk489a vto = -2.976
showmod jprb : vto beta
op
tran 1e-05 19.0 0 1e-05
wrdata rmai_g10t0_dpmaxmax_iii$d v(mainjack) v(fixjack1) v(fixjack2)
wrdata rmai_g10t0_dpmaxmax_iii_stati$d v(xls.xs) v(xlp.xs) v(dep) v(ina) v(vplus) v(vminus) v(main_a) v(mainc) v(fixc1) v(fixc2)
destroy all
echo "rmai_g10t0_dpmaxmax_iii,rmai_g10t0_dpmaxmax_iii.dat,rif_dpmaxmax,1000,0,10,100k,1.0,8.5,19.0,1e-05,rif_mai,-,-,0.0,3," >> tb_v2_casopeggiore_manifest.csv
alter vamp dc = 0
alter vfrq dc = 1000
alter rldm = 100k
alter rld1 = 100k
alter rld2 = 100k
alter vti dc = -10
alter vtr dc = 1000
alter vtijk dc = -10
alter vtrjk dc = 1000
alter vosa dc = 20m
alter vosb dc = 20m
alter vosf1 dc = 20m
alter vosf2 dc = -20m
alter ratth = 1m
alter rattb = 10k
alter rl1 = 845
alter cwire = 100p
alter vk1i dc = 1
alter vk1t dc = 1000.000000
alter vk5i dc = 1
alter vk5t dc = 1000.000000
alter vt1ri dc = 1
alter vt1rt dc = 1000.000000
alter vt1si dc = 0
alter vt1st dc = 1000.000000
alter vt2ri dc = 1
alter vt2rt dc = 1000.000000
alter vt2si dc = 0
alter vt2st dc = 1000.000000
alter vtijk dc = 1000.000000
alter vtrjk dc = 2000.000000
alter vksa dc = -10.000000
alter vksb dc = 1000.001000
alter vkca dc = -9.999000
alter vkcb dc = 1000.000000
alter vtiser dc = -10
alter vtrser dc = 1000
alter rbym = 1e12
alter rby1 = 1e12
alter rby2 = 1e12
alter rbcm = 220k
alter rbc1 = 470k
alter rbc2 = 470k
alter cksm = 0.1p
alter cks1 = 0.1p
alter cks2 = 0.1p
alter ccavm = 1e-18
alter ccav1 = 1e-18
alter ccav2 = 1e-18
print @cksm[capacitance] @cks1[capacitance] @cks2[capacitance] @ccavm[capacitance] @ccav1[capacitance] @ccav2[capacitance]
altermod lsk489a vto = -2.976
showmod jprb : vto beta
op
tran 1e-05 19.0 0 1e-05
wrdata rsempre_g10t0_dpmaxmax_iii$d v(mainjack) v(fixjack1) v(fixjack2)
wrdata rsempre_g10t0_dpmaxmax_iii_stati$d v(xls.xs) v(xlp.xs) v(dep) v(ina) v(vplus) v(vminus) v(main_a) v(mainc) v(fixc1) v(fixc2)
destroy all
echo "rsempre_g10t0_dpmaxmax_iii,rsempre_g10t0_dpmaxmax_iii.dat,rif_dpmaxmax,1000,0,10,100k,1.0,8.5,19.0,1e-05,rif_sempre,-,-,0.0,3," >> tb_v2_casopeggiore_manifest.csv
alter vamp dc = 0
alter vfrq dc = 1000
alter rldm = 100k
alter rld1 = 100k
alter rld2 = 100k
alter vti dc = 1000
alter vtr dc = 2000
alter vtijk dc = 1000
alter vtrjk dc = 2000
alter vosa dc = 20m
alter vosb dc = 20m
alter vosf1 dc = 20m
alter vosf2 dc = -20m
alter ratth = 1m
alter rattb = 10k
alter rl1 = 845
alter cwire = 100p
alter vk1i dc = 0
alter vk1t dc = 1000.000000
alter vk5i dc = 0
alter vk5t dc = 1000.000000
alter vt1ri dc = 1
alter vt1rt dc = 1000.000000
alter vt1si dc = 0
alter vt1st dc = 1000.000000
alter vt2ri dc = 1
alter vt2rt dc = 1000.000000
alter vt2si dc = 0
alter vt2st dc = 1000.000000
alter vtijk dc = 1000.000000
alter vtrjk dc = 2000.000000
alter vksa dc = 1000.000000
alter vksb dc = 2000.001000
alter vkca dc = 1000.001000
alter vkcb dc = 2000.000000
alter vtiser dc = -10
alter vtrser dc = 1000
alter rbym = 1e12
alter rby1 = 1e12
alter rby2 = 1e12
alter rbcm = 220k
alter rbc1 = 470k
alter rbc2 = 470k
alter cksm = 0.1p
alter cks1 = 0.1p
alter cks2 = 0.1p
alter ccavm = 1e-18
alter ccav1 = 1e-18
alter ccav2 = 1e-18
print @cksm[capacitance] @cks1[capacitance] @cks2[capacitance] @ccavm[capacitance] @ccav1[capacitance] @ccav2[capacitance]
altermod lsk489a vto = -2.976
showmod jprb : vto beta
op
tran 1e-05 19.0 0 1e-05
wrdata rmai_g0t0_dpmaxmax_iii$d v(mainjack) v(fixjack1) v(fixjack2)
wrdata rmai_g0t0_dpmaxmax_iii_stati$d v(xls.xs) v(xlp.xs) v(dep) v(ina) v(vplus) v(vminus) v(main_a) v(mainc) v(fixc1) v(fixc2)
destroy all
echo "rmai_g0t0_dpmaxmax_iii,rmai_g0t0_dpmaxmax_iii.dat,rif_dpmaxmax,1000,0,0,100k,1.0,8.5,19.0,1e-05,rif_mai,-,-,0.0,3," >> tb_v2_casopeggiore_manifest.csv
alter vamp dc = 0
alter vfrq dc = 1000
alter rldm = 100k
alter rld1 = 100k
alter rld2 = 100k
alter vti dc = -10
alter vtr dc = 1000
alter vtijk dc = -10
alter vtrjk dc = 1000
alter vosa dc = 20m
alter vosb dc = 20m
alter vosf1 dc = 20m
alter vosf2 dc = -20m
alter ratth = 1m
alter rattb = 10k
alter rl1 = 845
alter cwire = 100p
alter vk1i dc = 0
alter vk1t dc = 1000.000000
alter vk5i dc = 0
alter vk5t dc = 1000.000000
alter vt1ri dc = 1
alter vt1rt dc = 1000.000000
alter vt1si dc = 0
alter vt1st dc = 1000.000000
alter vt2ri dc = 1
alter vt2rt dc = 1000.000000
alter vt2si dc = 0
alter vt2st dc = 1000.000000
alter vtijk dc = 1000.000000
alter vtrjk dc = 2000.000000
alter vksa dc = -10.000000
alter vksb dc = 1000.001000
alter vkca dc = -9.999000
alter vkcb dc = 1000.000000
alter vtiser dc = -10
alter vtrser dc = 1000
alter rbym = 1e12
alter rby1 = 1e12
alter rby2 = 1e12
alter rbcm = 220k
alter rbc1 = 470k
alter rbc2 = 470k
alter cksm = 0.1p
alter cks1 = 0.1p
alter cks2 = 0.1p
alter ccavm = 1e-18
alter ccav1 = 1e-18
alter ccav2 = 1e-18
print @cksm[capacitance] @cks1[capacitance] @cks2[capacitance] @ccavm[capacitance] @ccav1[capacitance] @ccav2[capacitance]
altermod lsk489a vto = -2.976
showmod jprb : vto beta
op
tran 1e-05 19.0 0 1e-05
wrdata rsempre_g0t0_dpmaxmax_iii$d v(mainjack) v(fixjack1) v(fixjack2)
wrdata rsempre_g0t0_dpmaxmax_iii_stati$d v(xls.xs) v(xlp.xs) v(dep) v(ina) v(vplus) v(vminus) v(main_a) v(mainc) v(fixc1) v(fixc2)
destroy all
echo "rsempre_g0t0_dpmaxmax_iii,rsempre_g0t0_dpmaxmax_iii.dat,rif_dpmaxmax,1000,0,0,100k,1.0,8.5,19.0,1e-05,rif_sempre,-,-,0.0,3," >> tb_v2_casopeggiore_manifest.csv
alter vamp dc = 0
alter vfrq dc = 1000
alter rldm = 100k
alter rld1 = 100k
alter rld2 = 100k
alter vti dc = 1000
alter vtr dc = 2000
alter vtijk dc = 1000
alter vtrjk dc = 2000
alter vosa dc = 20m
alter vosb dc = 20m
alter vosf1 dc = 20m
alter vosf2 dc = -20m
alter ratth = 1m
alter rattb = 10k
alter rl1 = 845
alter cwire = 100p
alter vk1i dc = 1
alter vk1t dc = 1000.000000
alter vk5i dc = 1
alter vk5t dc = 1000.000000
alter vt1ri dc = 0
alter vt1rt dc = 1000.000000
alter vt1si dc = 1
alter vt1st dc = 1000.000000
alter vt2ri dc = 0
alter vt2rt dc = 1000.000000
alter vt2si dc = 1
alter vt2st dc = 1000.000000
alter vtijk dc = 1000.000000
alter vtrjk dc = 2000.000000
alter vksa dc = 1000.000000
alter vksb dc = 2000.001000
alter vkca dc = 1000.001000
alter vkcb dc = 2000.000000
alter vtiser dc = -10
alter vtrser dc = 1000
alter rbym = 1e12
alter rby1 = 1e12
alter rby2 = 1e12
alter rbcm = 220k
alter rbc1 = 470k
alter rbc2 = 470k
alter cksm = 0.1p
alter cks1 = 0.1p
alter cks2 = 0.1p
alter ccavm = 1e-18
alter ccav1 = 1e-18
alter ccav2 = 1e-18
print @cksm[capacitance] @cks1[capacitance] @cks2[capacitance] @ccavm[capacitance] @ccav1[capacitance] @ccav2[capacitance]
altermod lsk489a vto = -2.976
showmod jprb : vto beta
op
tran 1e-05 19.0 0 1e-05
wrdata rmai_g10t12_dpmaxmax_iii$d v(mainjack) v(fixjack1) v(fixjack2)
wrdata rmai_g10t12_dpmaxmax_iii_stati$d v(xls.xs) v(xlp.xs) v(dep) v(ina) v(vplus) v(vminus) v(main_a) v(mainc) v(fixc1) v(fixc2)
destroy all
echo "rmai_g10t12_dpmaxmax_iii,rmai_g10t12_dpmaxmax_iii.dat,rif_dpmaxmax,1000,0,10,100k,1.0,8.5,19.0,1e-05,rif_mai,-,-,0.0,3," >> tb_v2_casopeggiore_manifest.csv
alter vamp dc = 0
alter vfrq dc = 1000
alter rldm = 100k
alter rld1 = 100k
alter rld2 = 100k
alter vti dc = -10
alter vtr dc = 1000
alter vtijk dc = -10
alter vtrjk dc = 1000
alter vosa dc = 20m
alter vosb dc = 20m
alter vosf1 dc = 20m
alter vosf2 dc = -20m
alter ratth = 1m
alter rattb = 10k
alter rl1 = 845
alter cwire = 100p
alter vk1i dc = 1
alter vk1t dc = 1000.000000
alter vk5i dc = 1
alter vk5t dc = 1000.000000
alter vt1ri dc = 0
alter vt1rt dc = 1000.000000
alter vt1si dc = 1
alter vt1st dc = 1000.000000
alter vt2ri dc = 0
alter vt2rt dc = 1000.000000
alter vt2si dc = 1
alter vt2st dc = 1000.000000
alter vtijk dc = 1000.000000
alter vtrjk dc = 2000.000000
alter vksa dc = -10.000000
alter vksb dc = 1000.001000
alter vkca dc = -9.999000
alter vkcb dc = 1000.000000
alter vtiser dc = -10
alter vtrser dc = 1000
alter rbym = 1e12
alter rby1 = 1e12
alter rby2 = 1e12
alter rbcm = 220k
alter rbc1 = 470k
alter rbc2 = 470k
alter cksm = 0.1p
alter cks1 = 0.1p
alter cks2 = 0.1p
alter ccavm = 1e-18
alter ccav1 = 1e-18
alter ccav2 = 1e-18
print @cksm[capacitance] @cks1[capacitance] @cks2[capacitance] @ccavm[capacitance] @ccav1[capacitance] @ccav2[capacitance]
altermod lsk489a vto = -2.976
showmod jprb : vto beta
op
tran 1e-05 19.0 0 1e-05
wrdata rsempre_g10t12_dpmaxmax_iii$d v(mainjack) v(fixjack1) v(fixjack2)
wrdata rsempre_g10t12_dpmaxmax_iii_stati$d v(xls.xs) v(xlp.xs) v(dep) v(ina) v(vplus) v(vminus) v(main_a) v(mainc) v(fixc1) v(fixc2)
destroy all
echo "rsempre_g10t12_dpmaxmax_iii,rsempre_g10t12_dpmaxmax_iii.dat,rif_dpmaxmax,1000,0,10,100k,1.0,8.5,19.0,1e-05,rif_sempre,-,-,0.0,3," >> tb_v2_casopeggiore_manifest.csv
alter vamp dc = 0
alter vfrq dc = 1000
alter rldm = 100k
alter rld1 = 100k
alter rld2 = 100k
alter vti dc = 1.0
alter vtr dc = 10.0
alter vtijk dc = 7.5
alter vtrjk dc = 10.0
alter vosa dc = 20m
alter vosb dc = 20m
alter vosf1 dc = 20m
alter vosf2 dc = -20m
alter ratth = 1m
alter rattb = 10k
alter rl1 = 845
alter cwire = 100p
alter vk1i dc = 0
alter vk1t dc = 8.000300
alter vk5i dc = 0
alter vk5t dc = 8.000000
alter vt1ri dc = 1
alter vt1rt dc = 1000.000000
alter vt1si dc = 0
alter vt1st dc = 1000.000000
alter vt2ri dc = 1
alter vt2rt dc = 1000.000000
alter vt2si dc = 0
alter vt2st dc = 1000.000000
alter vtijk dc = 1000.000000
alter vtrjk dc = 2000.000000
alter vksa dc = 7.500000
alter vksb dc = 10.001000
alter vkca dc = 7.501000
alter vkcb dc = 10.000000
alter vtiser dc = -10
alter vtrser dc = 1000
alter rbym = 1e12
alter rby1 = 1e12
alter rby2 = 1e12
alter rbcm = 220k
alter rbc1 = 470k
alter rbc2 = 470k
alter cksm = 0.1p
alter cks1 = 0.1p
alter cks2 = 0.1p
alter ccavm = 1e-18
alter ccav1 = 1e-18
alter ccav2 = 1e-18
print @cksm[capacitance] @cks1[capacitance] @cks2[capacitance] @ccavm[capacitance] @ccav1[capacitance] @ccav2[capacitance]
altermod lsk489a vto = -2.976
showmod jprb : vto beta
op
tran 1e-05 19.0 0 1e-05
wrdata x01000_dpmaxmax_iii$d v(mainjack) v(fixjack1) v(fixjack2)
wrdata x01000_dpmaxmax_iii_stati$d v(xls.xs) v(xlp.xs) v(dep) v(ina) v(vplus) v(vminus) v(main_a) v(mainc) v(fixc1) v(fixc2)
destroy all
echo "x01000_dpmaxmax_iii_i,x01000_dpmaxmax_iii.dat,l29d2_iii_dpmaxmax,1000,0,g0a10_t0a0,100k,1.0,8.0,19.0,1e-05,evento,rsempre_g0t0_dpmaxmax_iii,rmai_g0t0_dpmaxmax_iii,6.5,3,A_ins;B2" >> tb_v2_casopeggiore_manifest.csv
echo "x01000_dpmaxmax_iii_c,x01000_dpmaxmax_iii.dat,l29d2_iii_dpmaxmax,1000,0,g0a10_t0a0,100k,8.0,10.0,19.0,1e-05,evento,rsempre_g10t0_dpmaxmax_iii,rmai_g10t0_dpmaxmax_iii,0.0,3,A_ins;A_rel;B2" >> tb_v2_casopeggiore_manifest.csv
alter vamp dc = 0
alter vfrq dc = 1000
alter rldm = 100k
alter rld1 = 100k
alter rld2 = 100k
alter vti dc = 1.0
alter vtr dc = 10.0
alter vtijk dc = 7.5
alter vtrjk dc = 10.0
alter vosa dc = 20m
alter vosb dc = 20m
alter vosf1 dc = 20m
alter vosf2 dc = -20m
alter ratth = 1m
alter rattb = 10k
alter rl1 = 845
alter cwire = 100p
alter vk1i dc = 1
alter vk1t dc = 8.000000
alter vk5i dc = 1
alter vk5t dc = 8.000300
alter vt1ri dc = 1
alter vt1rt dc = 1000.000000
alter vt1si dc = 0
alter vt1st dc = 1000.000000
alter vt2ri dc = 1
alter vt2rt dc = 1000.000000
alter vt2si dc = 0
alter vt2st dc = 1000.000000
alter vtijk dc = 1000.000000
alter vtrjk dc = 2000.000000
alter vksa dc = 7.500000
alter vksb dc = 10.001000
alter vkca dc = 7.501000
alter vkcb dc = 10.000000
alter vtiser dc = -10
alter vtrser dc = 1000
alter rbym = 1e12
alter rby1 = 1e12
alter rby2 = 1e12
alter rbcm = 220k
alter rbc1 = 470k
alter rbc2 = 470k
alter cksm = 0.1p
alter cks1 = 0.1p
alter cks2 = 0.1p
alter ccavm = 1e-18
alter ccav1 = 1e-18
alter ccav2 = 1e-18
print @cksm[capacitance] @cks1[capacitance] @cks2[capacitance] @ccavm[capacitance] @ccav1[capacitance] @ccav2[capacitance]
altermod lsk489a vto = -2.976
showmod jprb : vto beta
op
tran 1e-05 19.0 0 1e-05
wrdata x10000_dpmaxmax_iii$d v(mainjack) v(fixjack1) v(fixjack2)
wrdata x10000_dpmaxmax_iii_stati$d v(xls.xs) v(xlp.xs) v(dep) v(ina) v(vplus) v(vminus) v(main_a) v(mainc) v(fixc1) v(fixc2)
destroy all
echo "x10000_dpmaxmax_iii_i,x10000_dpmaxmax_iii.dat,l29d2_iii_dpmaxmax,1000,0,g10a0_t0a0,100k,1.0,8.0,19.0,1e-05,evento,rsempre_g10t0_dpmaxmax_iii,rmai_g10t0_dpmaxmax_iii,6.5,3,A_ins;B2" >> tb_v2_casopeggiore_manifest.csv
echo "x10000_dpmaxmax_iii_c,x10000_dpmaxmax_iii.dat,l29d2_iii_dpmaxmax,1000,0,g10a0_t0a0,100k,8.0,10.0,19.0,1e-05,evento,rsempre_g0t0_dpmaxmax_iii,rmai_g0t0_dpmaxmax_iii,0.0,3,A_ins;A_rel;B2" >> tb_v2_casopeggiore_manifest.csv
alter vamp dc = 0
alter vfrq dc = 1000
alter rldm = 100k
alter rld1 = 100k
alter rld2 = 100k
alter vti dc = 1.0
alter vtr dc = 10.0
alter vtijk dc = 7.5
alter vtrjk dc = 10.0
alter vosa dc = 20m
alter vosb dc = 20m
alter vosf1 dc = 20m
alter vosf2 dc = -20m
alter ratth = 1m
alter rattb = 10k
alter rl1 = 845
alter cwire = 100p
alter vk1i dc = 1
alter vk1t dc = 1000.000000
alter vk5i dc = 1
alter vk5t dc = 1000.000000
alter vt1ri dc = 1
alter vt1rt dc = 8.000000
alter vt1si dc = 0
alter vt1st dc = 8.001000
alter vt2ri dc = 1
alter vt2rt dc = 8.000000
alter vt2si dc = 0
alter vt2st dc = 8.001000
alter vtijk dc = 1000.000000
alter vtrjk dc = 2000.000000
alter vksa dc = 7.500000
alter vksb dc = 10.001000
alter vkca dc = 7.501000
alter vkcb dc = 10.000000
alter vtiser dc = -10
alter vtrser dc = 1000
alter rbym = 1e12
alter rby1 = 1e12
alter rby2 = 1e12
alter rbcm = 220k
alter rbc1 = 470k
alter rbc2 = 470k
alter cksm = 0.1p
alter cks1 = 0.1p
alter cks2 = 0.1p
alter ccavm = 1e-18
alter ccav1 = 1e-18
alter ccav2 = 1e-18
print @cksm[capacitance] @cks1[capacitance] @cks2[capacitance] @ccavm[capacitance] @ccav1[capacitance] @ccav2[capacitance]
altermod lsk489a vto = -2.976
showmod jprb : vto beta
op
tran 1e-05 19.0 0 1e-05
wrdata x1010012_dpmaxmax_iii$d v(mainjack) v(fixjack1) v(fixjack2)
wrdata x1010012_dpmaxmax_iii_stati$d v(xls.xs) v(xlp.xs) v(dep) v(ina) v(vplus) v(vminus) v(main_a) v(mainc) v(fixc1) v(fixc2)
destroy all
echo "x1010012_dpmaxmax_iii_i,x1010012_dpmaxmax_iii.dat,l29d2_iii_dpmaxmax,1000,0,g10a10_t0a12,100k,1.0,8.0,19.0,1e-05,evento,rsempre_g10t0_dpmaxmax_iii,rmai_g10t0_dpmaxmax_iii,6.5,3,A_ins;B2" >> tb_v2_casopeggiore_manifest.csv
echo "x1010012_dpmaxmax_iii_c,x1010012_dpmaxmax_iii.dat,l29d2_iii_dpmaxmax,1000,0,g10a10_t0a12,100k,8.0,10.0,19.0,1e-05,evento,rsempre_g10t12_dpmaxmax_iii,rmai_g10t12_dpmaxmax_iii,0.0,3,A_ins;A_rel;B2" >> tb_v2_casopeggiore_manifest.csv
alter vamp dc = 0
alter vfrq dc = 1000
alter rldm = 100k
alter rld1 = 100k
alter rld2 = 100k
alter vti dc = 1.0
alter vtr dc = 10.0
alter vtijk dc = 7.5
alter vtrjk dc = 10.0
alter vosa dc = 20m
alter vosb dc = 20m
alter vosf1 dc = 20m
alter vosf2 dc = -20m
alter ratth = 1m
alter rattb = 10k
alter rl1 = 845
alter cwire = 100p
alter vk1i dc = 1
alter vk1t dc = 1000.000000
alter vk5i dc = 1
alter vk5t dc = 1000.000000
alter vt1ri dc = 0
alter vt1rt dc = 8.001000
alter vt1si dc = 1
alter vt1st dc = 8.000000
alter vt2ri dc = 0
alter vt2rt dc = 8.001000
alter vt2si dc = 1
alter vt2st dc = 8.000000
alter vtijk dc = 1000.000000
alter vtrjk dc = 2000.000000
alter vksa dc = 7.500000
alter vksb dc = 10.001000
alter vkca dc = 7.501000
alter vkcb dc = 10.000000
alter vtiser dc = -10
alter vtrser dc = 1000
alter rbym = 1e12
alter rby1 = 1e12
alter rby2 = 1e12
alter rbcm = 220k
alter rbc1 = 470k
alter rbc2 = 470k
alter cksm = 0.1p
alter cks1 = 0.1p
alter cks2 = 0.1p
alter ccavm = 1e-18
alter ccav1 = 1e-18
alter ccav2 = 1e-18
print @cksm[capacitance] @cks1[capacitance] @cks2[capacitance] @ccavm[capacitance] @ccav1[capacitance] @ccav2[capacitance]
altermod lsk489a vto = -2.976
showmod jprb : vto beta
op
tran 1e-05 19.0 0 1e-05
wrdata x1010120_dpmaxmax_iii$d v(mainjack) v(fixjack1) v(fixjack2)
wrdata x1010120_dpmaxmax_iii_stati$d v(xls.xs) v(xlp.xs) v(dep) v(ina) v(vplus) v(vminus) v(main_a) v(mainc) v(fixc1) v(fixc2)
destroy all
echo "x1010120_dpmaxmax_iii_i,x1010120_dpmaxmax_iii.dat,l29d2_iii_dpmaxmax,1000,0,g10a10_t12a0,100k,1.0,8.0,19.0,1e-05,evento,rsempre_g10t12_dpmaxmax_iii,rmai_g10t12_dpmaxmax_iii,6.5,3,A_ins;B2" >> tb_v2_casopeggiore_manifest.csv
echo "x1010120_dpmaxmax_iii_c,x1010120_dpmaxmax_iii.dat,l29d2_iii_dpmaxmax,1000,0,g10a10_t12a0,100k,8.0,10.0,19.0,1e-05,evento,rsempre_g10t0_dpmaxmax_iii,rmai_g10t0_dpmaxmax_iii,0.0,3,A_ins;A_rel;B2" >> tb_v2_casopeggiore_manifest.csv
alter vamp dc = 0
alter vfrq dc = 1000
alter rldm = 100k
alter rld1 = 100k
alter rld2 = 100k
alter vti dc = 1.0
alter vtr dc = 8.5
alter vtijk dc = 7.5
alter vtrjk dc = 8.5
alter vosa dc = 20m
alter vosb dc = 20m
alter vosf1 dc = 20m
alter vosf2 dc = -20m
alter ratth = 1m
alter rattb = 10k
alter rl1 = 845
alter cwire = 100p
alter vk1i dc = 1
alter vk1t dc = 1000.000000
alter vk5i dc = 1
alter vk5t dc = 1000.000000
alter vt1ri dc = 1
alter vt1rt dc = 1000.000000
alter vt1si dc = 0
alter vt1st dc = 1000.000000
alter vt2ri dc = 1
alter vt2rt dc = 1000.000000
alter vt2si dc = 0
alter vt2st dc = 1000.000000
alter vtijk dc = 1000.000000
alter vtrjk dc = 2000.000000
alter vksa dc = 7.500000
alter vksb dc = 8.501000
alter vkca dc = 7.501000
alter vkcb dc = 8.500000
alter vtiser dc = -10
alter vtrser dc = 1000
alter rbym = 1e12
alter rby1 = 1e12
alter rby2 = 1e12
alter rbcm = 220k
alter rbc1 = 470k
alter rbc2 = 470k
alter cksm = 0.1p
alter cks1 = 0.1p
alter cks2 = 0.1p
alter ccavm = 1e-18
alter ccav1 = 1e-18
alter ccav2 = 1e-18
print @cksm[capacitance] @cks1[capacitance] @cks2[capacitance] @ccavm[capacitance] @ccav1[capacitance] @ccav2[capacitance]
altermod lsk489a vto = -2.976
showmod jprb : vto beta
op
tran 1e-05 17.5 0 1e-05
wrdata xm_dpmaxmax_iii$d v(mainjack) v(fixjack1) v(fixjack2)
wrdata xm_dpmaxmax_iii_stati$d v(xls.xs) v(xlp.xs) v(dep) v(ina) v(vplus) v(vminus) v(main_a) v(mainc) v(fixc1) v(fixc2)
destroy all
echo "xm_dpmaxmax_iii,xm_dpmaxmax_iii.dat,l29d2_iii_dpmaxmax,1000,0,10,100k,1.0,8.5,17.5,1e-05,evento,rsempre_g10t0_dpmaxmax_iii,rmai_g10t0_dpmaxmax_iii,6.5,3,A_ins;A_rel;B2" >> tb_v2_casopeggiore_manifest.csv
* ---- L29d2 4: mh01_1k_iii ----
alter vamp dc = 3.818
alter vfrq dc = 1000
alter rldm = 100k
alter rld1 = 100k
alter rld2 = 100k
alter vti dc = 1.0
alter vtr dc = 7.6
alter vtijk dc = 7.5
alter vtrjk dc = 7.6
alter vosa dc = 0
alter vosb dc = 0
alter vosf1 dc = 0
alter vosf2 dc = 0
alter ratth = 1m
alter rattb = 10k
alter rl1 = 845
alter cwire = 100p
alter vk1i dc = 1
alter vk1t dc = 1000.000000
alter vk5i dc = 1
alter vk5t dc = 1000.000000
alter vt1ri dc = 1
alter vt1rt dc = 1000.000000
alter vt1si dc = 0
alter vt1st dc = 1000.000000
alter vt2ri dc = 1
alter vt2rt dc = 1000.000000
alter vt2si dc = 0
alter vt2st dc = 1000.000000
alter vtijk dc = 1000.000000
alter vtrjk dc = 2000.000000
alter vksa dc = 7.500000
alter vksb dc = 7.601000
alter vkca dc = 7.501000
alter vkcb dc = 7.600000
alter vtiser dc = -10
alter vtrser dc = 1000
alter rbym = 1e12
alter rby1 = 1e12
alter rby2 = 1e12
alter rbcm = 220k
alter rbc1 = 470k
alter rbc2 = 470k
alter cksm = 0.1p
alter cks1 = 0.1p
alter cks2 = 0.1p
alter ccavm = 1e-18
alter ccav1 = 1e-18
alter ccav2 = 1e-18
print @cksm[capacitance] @cks1[capacitance] @cks2[capacitance] @ccavm[capacitance] @ccav1[capacitance] @ccav2[capacitance]
tran 1e-05 16.6 0 1e-05
wrdata mh01_1k_iii$d v(mainjack) v(fixjack1) v(fixjack2)
wrdata mh01_1k_iii_stati$d v(xls.xs) v(xlp.xs) v(dep) v(ina) v(vplus) v(vminus) v(main_a) v(mainc) v(fixc1) v(fixc2)
destroy all
echo "mh01_1k_iii,mh01_1k_iii.dat,l29d2_iii_h01,1000,3.818,10,100k,1.0,7.6,16.6,1e-05,evento,g10sempre_1k_iii,g10mai_1k_iii,6.5,4,S_ins;S_rel;B2" >> tb_v2_casopeggiore_manifest.csv
* ---- L29d2 4: mev_1k_iii ----
alter vamp dc = 3.818
alter vfrq dc = 1000
alter rldm = 100k
alter rld1 = 100k
alter rld2 = 100k
alter vti dc = 1.0
alter vtr dc = 8.5
alter vtijk dc = 7.5
alter vtrjk dc = 8.5
alter vosa dc = 0
alter vosb dc = 0
alter vosf1 dc = 0
alter vosf2 dc = 0
alter ratth = 1m
alter rattb = 10k
alter rl1 = 845
alter cwire = 100p
alter vk1i dc = 1
alter vk1t dc = 1000.000000
alter vk5i dc = 1
alter vk5t dc = 1000.000000
alter vt1ri dc = 1
alter vt1rt dc = 1000.000000
alter vt1si dc = 0
alter vt1st dc = 1000.000000
alter vt2ri dc = 1
alter vt2rt dc = 1000.000000
alter vt2si dc = 0
alter vt2st dc = 1000.000000
alter vtijk dc = 1000.000000
alter vtrjk dc = 2000.000000
alter vksa dc = 7.500000
alter vksb dc = 8.501000
alter vkca dc = 7.501000
alter vkcb dc = 8.500000
alter vtiser dc = -10
alter vtrser dc = 1000
alter rbym = 1e12
alter rby1 = 1e12
alter rby2 = 1e12
alter rbcm = 220k
alter rbc1 = 470k
alter rbc2 = 470k
alter cksm = 0.1p
alter cks1 = 0.1p
alter cks2 = 0.1p
alter ccavm = 1e-18
alter ccav1 = 1e-18
alter ccav2 = 1e-18
print @cksm[capacitance] @cks1[capacitance] @cks2[capacitance] @ccavm[capacitance] @ccav1[capacitance] @ccav2[capacitance]
tran 1e-05 17.5 0 1e-05
wrdata mev_1k_iii$d v(mainjack) v(fixjack1) v(fixjack2)
wrdata mev_1k_iii_stati$d v(xls.xs) v(xlp.xs) v(dep) v(ina) v(vplus) v(vminus) v(main_a) v(mainc) v(fixc1) v(fixc2)
destroy all
echo "mev_1k_iii,mev_1k_iii.dat,l29d2_iii_ev,1000,3.818,10,100k,1.0,8.5,17.5,1e-05,evento,g10sempre_1k_iii,g10mai_1k_iii,6.5,4,S_ins;S_rel;B2" >> tb_v2_casopeggiore_manifest.csv
* ---- L29d2 4: mh2_1k_iii ----
alter vamp dc = 3.818
alter vfrq dc = 1000
alter rldm = 100k
alter rld1 = 100k
alter rld2 = 100k
alter vti dc = 1.0
alter vtr dc = 9.5
alter vtijk dc = 7.5
alter vtrjk dc = 9.5
alter vosa dc = 0
alter vosb dc = 0
alter vosf1 dc = 0
alter vosf2 dc = 0
alter ratth = 1m
alter rattb = 10k
alter rl1 = 845
alter cwire = 100p
alter vk1i dc = 1
alter vk1t dc = 1000.000000
alter vk5i dc = 1
alter vk5t dc = 1000.000000
alter vt1ri dc = 1
alter vt1rt dc = 1000.000000
alter vt1si dc = 0
alter vt1st dc = 1000.000000
alter vt2ri dc = 1
alter vt2rt dc = 1000.000000
alter vt2si dc = 0
alter vt2st dc = 1000.000000
alter vtijk dc = 1000.000000
alter vtrjk dc = 2000.000000
alter vksa dc = 7.500000
alter vksb dc = 9.501000
alter vkca dc = 7.501000
alter vkcb dc = 9.500000
alter vtiser dc = -10
alter vtrser dc = 1000
alter rbym = 1e12
alter rby1 = 1e12
alter rby2 = 1e12
alter rbcm = 220k
alter rbc1 = 470k
alter rbc2 = 470k
alter cksm = 0.1p
alter cks1 = 0.1p
alter cks2 = 0.1p
alter ccavm = 1e-18
alter ccav1 = 1e-18
alter ccav2 = 1e-18
print @cksm[capacitance] @cks1[capacitance] @cks2[capacitance] @ccavm[capacitance] @ccav1[capacitance] @ccav2[capacitance]
tran 1e-05 18.5 0 1e-05
wrdata mh2_1k_iii$d v(mainjack) v(fixjack1) v(fixjack2)
wrdata mh2_1k_iii_stati$d v(xls.xs) v(xlp.xs) v(dep) v(ina) v(vplus) v(vminus) v(main_a) v(mainc) v(fixc1) v(fixc2)
destroy all
echo "mh2_1k_iii,mh2_1k_iii.dat,l29d2_iii_h2,1000,3.818,10,100k,1.0,9.5,18.5,1e-05,evento,g10sempre_1k_iii,g10mai_1k_iii,6.5,4,S_ins;S_rel;B2" >> tb_v2_casopeggiore_manifest.csv
* ---- L29d2 4: mh20_1k_iii ----
alter vamp dc = 3.818
alter vfrq dc = 1000
alter rldm = 100k
alter rld1 = 100k
alter rld2 = 100k
alter vti dc = 1.0
alter vtr dc = 27.5
alter vtijk dc = 7.5
alter vtrjk dc = 27.5
alter vosa dc = 0
alter vosb dc = 0
alter vosf1 dc = 0
alter vosf2 dc = 0
alter ratth = 1m
alter rattb = 10k
alter rl1 = 845
alter cwire = 100p
alter vk1i dc = 1
alter vk1t dc = 1000.000000
alter vk5i dc = 1
alter vk5t dc = 1000.000000
alter vt1ri dc = 1
alter vt1rt dc = 1000.000000
alter vt1si dc = 0
alter vt1st dc = 1000.000000
alter vt2ri dc = 1
alter vt2rt dc = 1000.000000
alter vt2si dc = 0
alter vt2st dc = 1000.000000
alter vtijk dc = 1000.000000
alter vtrjk dc = 2000.000000
alter vksa dc = 7.500000
alter vksb dc = 27.501000
alter vkca dc = 7.501000
alter vkcb dc = 27.500000
alter vtiser dc = -10
alter vtrser dc = 1000
alter rbym = 1e12
alter rby1 = 1e12
alter rby2 = 1e12
alter rbcm = 220k
alter rbc1 = 470k
alter rbc2 = 470k
alter cksm = 0.1p
alter cks1 = 0.1p
alter cks2 = 0.1p
alter ccavm = 1e-18
alter ccav1 = 1e-18
alter ccav2 = 1e-18
print @cksm[capacitance] @cks1[capacitance] @cks2[capacitance] @ccavm[capacitance] @ccav1[capacitance] @ccav2[capacitance]
tran 1e-05 36.5 0 1e-05
wrdata mh20_1k_iii$d v(mainjack) v(fixjack1) v(fixjack2)
wrdata mh20_1k_iii_stati$d v(xls.xs) v(xlp.xs) v(dep) v(ina) v(vplus) v(vminus) v(main_a) v(mainc) v(fixc1) v(fixc2)
destroy all
echo "mh20_1k_iii,mh20_1k_iii.dat,l29d2_iii_h20,1000,3.818,10,100k,1.0,27.5,36.5,1e-05,evento,g10sempre_1k_iii,g10mai_1k_iii,6.5,4,S_ins;S_rel;B2" >> tb_v2_casopeggiore_manifest.csv
alter vamp dc = 3.818
alter vfrq dc = 1000
alter rldm = 100k
alter rld1 = 100k
alter rld2 = 100k
alter vti dc = 1.0
alter vtr dc = 8.5
alter vtijk dc = 1000
alter vtrjk dc = 2000
alter vosa dc = 0
alter vosb dc = 0
alter vosf1 dc = 0
alter vosf2 dc = 0
alter ratth = 1m
alter rattb = 10k
alter rl1 = 845
alter cwire = 100p
alter vk1i dc = 1
alter vk1t dc = 1000.000000
alter vk5i dc = 1
alter vk5t dc = 1000.000000
alter vt1ri dc = 1
alter vt1rt dc = 1000.000000
alter vt1si dc = 0
alter vt1st dc = 1000.000000
alter vt2ri dc = 1
alter vt2rt dc = 1000.000000
alter vt2si dc = 0
alter vt2st dc = 1000.000000
alter vtijk dc = 1000.000000
alter vtrjk dc = 2000.000000
alter vksa dc = 1000.000000
alter vksb dc = 2000.001000
alter vkca dc = 1000.001000
alter vkcb dc = 2000.000000
alter vtiser dc = -10
alter vtrser dc = 1000
alter rbym = 1e12
alter rby1 = 1e12
alter rby2 = 1e12
alter rbcm = 220k
alter rbc1 = 470k
alter rbc2 = 470k
alter cksm = 0.1p
alter cks1 = 0.1p
alter cks2 = 0.1p
alter ccavm = 1e-18
alter ccav1 = 1e-18
alter ccav2 = 1e-18
print @cksm[capacitance] @cks1[capacitance] @cks2[capacitance] @ccavm[capacitance] @ccav1[capacitance] @ccav2[capacitance]
tran 1e-05 17.5 0 1e-05
wrdata mnorele_1k_iii$d v(mainjack) v(fixjack1) v(fixjack2)
wrdata mnorele_1k_iii_stati$d v(xls.xs) v(xlp.xs) v(dep) v(ina) v(vplus) v(vminus) v(main_a) v(mainc) v(fixc1) v(fixc2)
destroy all
echo "mnorele_1k_iii,mnorele_1k_iii.dat,rif,1000,3.818,10,100k,1.0,8.5,17.5,1e-05,rif_seq,-,-,0.0,0," >> tb_v2_casopeggiore_manifest.csv
echo "rele_1k_iii,mev_1k_iii.dat,rele_contro_norele,1000,3.818,10,100k,7.5,8.5,17.5,1e-05,evento,mnorele_1k_iii,mnorele_1k_iii,0.0,4,S_ins;S_rel" >> tb_v2_casopeggiore_manifest.csv
* ---- L29d2 4: mh01_20_iii ----
alter vamp dc = 3.818
alter vfrq dc = 20
alter rldm = 100k
alter rld1 = 100k
alter rld2 = 100k
alter vti dc = 1.0
alter vtr dc = 7.6
alter vtijk dc = 7.5
alter vtrjk dc = 7.6
alter vosa dc = 0
alter vosb dc = 0
alter vosf1 dc = 0
alter vosf2 dc = 0
alter ratth = 1m
alter rattb = 10k
alter rl1 = 845
alter cwire = 100p
alter vk1i dc = 1
alter vk1t dc = 1000.000000
alter vk5i dc = 1
alter vk5t dc = 1000.000000
alter vt1ri dc = 1
alter vt1rt dc = 1000.000000
alter vt1si dc = 0
alter vt1st dc = 1000.000000
alter vt2ri dc = 1
alter vt2rt dc = 1000.000000
alter vt2si dc = 0
alter vt2st dc = 1000.000000
alter vtijk dc = 1000.000000
alter vtrjk dc = 2000.000000
alter vksa dc = 7.500000
alter vksb dc = 7.601000
alter vkca dc = 7.501000
alter vkcb dc = 7.600000
alter vtiser dc = -10
alter vtrser dc = 1000
alter rbym = 1e12
alter rby1 = 1e12
alter rby2 = 1e12
alter rbcm = 220k
alter rbc1 = 470k
alter rbc2 = 470k
alter cksm = 0.1p
alter cks1 = 0.1p
alter cks2 = 0.1p
alter ccavm = 1e-18
alter ccav1 = 1e-18
alter ccav2 = 1e-18
print @cksm[capacitance] @cks1[capacitance] @cks2[capacitance] @ccavm[capacitance] @ccav1[capacitance] @ccav2[capacitance]
tran 1e-05 16.6 0 1e-05
wrdata mh01_20_iii$d v(mainjack) v(fixjack1) v(fixjack2)
wrdata mh01_20_iii_stati$d v(xls.xs) v(xlp.xs) v(dep) v(ina) v(vplus) v(vminus) v(main_a) v(mainc) v(fixc1) v(fixc2)
destroy all
echo "mh01_20_iii,mh01_20_iii.dat,l29d2_iii_h01,20,3.818,10,100k,1.0,7.6,16.6,1e-05,evento,g10sempre_20_iii,g10mai_20_iii,6.5,4,S_ins;S_rel;B2" >> tb_v2_casopeggiore_manifest.csv
* ---- L29d2 4: mev_20_iii ----
alter vamp dc = 3.818
alter vfrq dc = 20
alter rldm = 100k
alter rld1 = 100k
alter rld2 = 100k
alter vti dc = 1.0
alter vtr dc = 8.5
alter vtijk dc = 7.5
alter vtrjk dc = 8.5
alter vosa dc = 0
alter vosb dc = 0
alter vosf1 dc = 0
alter vosf2 dc = 0
alter ratth = 1m
alter rattb = 10k
alter rl1 = 845
alter cwire = 100p
alter vk1i dc = 1
alter vk1t dc = 1000.000000
alter vk5i dc = 1
alter vk5t dc = 1000.000000
alter vt1ri dc = 1
alter vt1rt dc = 1000.000000
alter vt1si dc = 0
alter vt1st dc = 1000.000000
alter vt2ri dc = 1
alter vt2rt dc = 1000.000000
alter vt2si dc = 0
alter vt2st dc = 1000.000000
alter vtijk dc = 1000.000000
alter vtrjk dc = 2000.000000
alter vksa dc = 7.500000
alter vksb dc = 8.501000
alter vkca dc = 7.501000
alter vkcb dc = 8.500000
alter vtiser dc = -10
alter vtrser dc = 1000
alter rbym = 1e12
alter rby1 = 1e12
alter rby2 = 1e12
alter rbcm = 220k
alter rbc1 = 470k
alter rbc2 = 470k
alter cksm = 0.1p
alter cks1 = 0.1p
alter cks2 = 0.1p
alter ccavm = 1e-18
alter ccav1 = 1e-18
alter ccav2 = 1e-18
print @cksm[capacitance] @cks1[capacitance] @cks2[capacitance] @ccavm[capacitance] @ccav1[capacitance] @ccav2[capacitance]
tran 1e-05 17.5 0 1e-05
wrdata mev_20_iii$d v(mainjack) v(fixjack1) v(fixjack2)
wrdata mev_20_iii_stati$d v(xls.xs) v(xlp.xs) v(dep) v(ina) v(vplus) v(vminus) v(main_a) v(mainc) v(fixc1) v(fixc2)
destroy all
echo "mev_20_iii,mev_20_iii.dat,l29d2_iii_ev,20,3.818,10,100k,1.0,8.5,17.5,1e-05,evento,g10sempre_20_iii,g10mai_20_iii,6.5,4,S_ins;S_rel;B2" >> tb_v2_casopeggiore_manifest.csv
* ---- L29d2 4: mh2_20_iii ----
alter vamp dc = 3.818
alter vfrq dc = 20
alter rldm = 100k
alter rld1 = 100k
alter rld2 = 100k
alter vti dc = 1.0
alter vtr dc = 9.5
alter vtijk dc = 7.5
alter vtrjk dc = 9.5
alter vosa dc = 0
alter vosb dc = 0
alter vosf1 dc = 0
alter vosf2 dc = 0
alter ratth = 1m
alter rattb = 10k
alter rl1 = 845
alter cwire = 100p
alter vk1i dc = 1
alter vk1t dc = 1000.000000
alter vk5i dc = 1
alter vk5t dc = 1000.000000
alter vt1ri dc = 1
alter vt1rt dc = 1000.000000
alter vt1si dc = 0
alter vt1st dc = 1000.000000
alter vt2ri dc = 1
alter vt2rt dc = 1000.000000
alter vt2si dc = 0
alter vt2st dc = 1000.000000
alter vtijk dc = 1000.000000
alter vtrjk dc = 2000.000000
alter vksa dc = 7.500000
alter vksb dc = 9.501000
alter vkca dc = 7.501000
alter vkcb dc = 9.500000
alter vtiser dc = -10
alter vtrser dc = 1000
alter rbym = 1e12
alter rby1 = 1e12
alter rby2 = 1e12
alter rbcm = 220k
alter rbc1 = 470k
alter rbc2 = 470k
alter cksm = 0.1p
alter cks1 = 0.1p
alter cks2 = 0.1p
alter ccavm = 1e-18
alter ccav1 = 1e-18
alter ccav2 = 1e-18
print @cksm[capacitance] @cks1[capacitance] @cks2[capacitance] @ccavm[capacitance] @ccav1[capacitance] @ccav2[capacitance]
tran 1e-05 18.5 0 1e-05
wrdata mh2_20_iii$d v(mainjack) v(fixjack1) v(fixjack2)
wrdata mh2_20_iii_stati$d v(xls.xs) v(xlp.xs) v(dep) v(ina) v(vplus) v(vminus) v(main_a) v(mainc) v(fixc1) v(fixc2)
destroy all
echo "mh2_20_iii,mh2_20_iii.dat,l29d2_iii_h2,20,3.818,10,100k,1.0,9.5,18.5,1e-05,evento,g10sempre_20_iii,g10mai_20_iii,6.5,4,S_ins;S_rel;B2" >> tb_v2_casopeggiore_manifest.csv
* ---- L29d2 4: mh20_20_iii ----
alter vamp dc = 3.818
alter vfrq dc = 20
alter rldm = 100k
alter rld1 = 100k
alter rld2 = 100k
alter vti dc = 1.0
alter vtr dc = 27.5
alter vtijk dc = 7.5
alter vtrjk dc = 27.5
alter vosa dc = 0
alter vosb dc = 0
alter vosf1 dc = 0
alter vosf2 dc = 0
alter ratth = 1m
alter rattb = 10k
alter rl1 = 845
alter cwire = 100p
alter vk1i dc = 1
alter vk1t dc = 1000.000000
alter vk5i dc = 1
alter vk5t dc = 1000.000000
alter vt1ri dc = 1
alter vt1rt dc = 1000.000000
alter vt1si dc = 0
alter vt1st dc = 1000.000000
alter vt2ri dc = 1
alter vt2rt dc = 1000.000000
alter vt2si dc = 0
alter vt2st dc = 1000.000000
alter vtijk dc = 1000.000000
alter vtrjk dc = 2000.000000
alter vksa dc = 7.500000
alter vksb dc = 27.501000
alter vkca dc = 7.501000
alter vkcb dc = 27.500000
alter vtiser dc = -10
alter vtrser dc = 1000
alter rbym = 1e12
alter rby1 = 1e12
alter rby2 = 1e12
alter rbcm = 220k
alter rbc1 = 470k
alter rbc2 = 470k
alter cksm = 0.1p
alter cks1 = 0.1p
alter cks2 = 0.1p
alter ccavm = 1e-18
alter ccav1 = 1e-18
alter ccav2 = 1e-18
print @cksm[capacitance] @cks1[capacitance] @cks2[capacitance] @ccavm[capacitance] @ccav1[capacitance] @ccav2[capacitance]
tran 1e-05 36.5 0 1e-05
wrdata mh20_20_iii$d v(mainjack) v(fixjack1) v(fixjack2)
wrdata mh20_20_iii_stati$d v(xls.xs) v(xlp.xs) v(dep) v(ina) v(vplus) v(vminus) v(main_a) v(mainc) v(fixc1) v(fixc2)
destroy all
echo "mh20_20_iii,mh20_20_iii.dat,l29d2_iii_h20,20,3.818,10,100k,1.0,27.5,36.5,1e-05,evento,g10sempre_20_iii,g10mai_20_iii,6.5,4,S_ins;S_rel;B2" >> tb_v2_casopeggiore_manifest.csv
alter vamp dc = 3.818
alter vfrq dc = 20
alter rldm = 100k
alter rld1 = 100k
alter rld2 = 100k
alter vti dc = 1.0
alter vtr dc = 8.5
alter vtijk dc = 1000
alter vtrjk dc = 2000
alter vosa dc = 0
alter vosb dc = 0
alter vosf1 dc = 0
alter vosf2 dc = 0
alter ratth = 1m
alter rattb = 10k
alter rl1 = 845
alter cwire = 100p
alter vk1i dc = 1
alter vk1t dc = 1000.000000
alter vk5i dc = 1
alter vk5t dc = 1000.000000
alter vt1ri dc = 1
alter vt1rt dc = 1000.000000
alter vt1si dc = 0
alter vt1st dc = 1000.000000
alter vt2ri dc = 1
alter vt2rt dc = 1000.000000
alter vt2si dc = 0
alter vt2st dc = 1000.000000
alter vtijk dc = 1000.000000
alter vtrjk dc = 2000.000000
alter vksa dc = 1000.000000
alter vksb dc = 2000.001000
alter vkca dc = 1000.001000
alter vkcb dc = 2000.000000
alter vtiser dc = -10
alter vtrser dc = 1000
alter rbym = 1e12
alter rby1 = 1e12
alter rby2 = 1e12
alter rbcm = 220k
alter rbc1 = 470k
alter rbc2 = 470k
alter cksm = 0.1p
alter cks1 = 0.1p
alter cks2 = 0.1p
alter ccavm = 1e-18
alter ccav1 = 1e-18
alter ccav2 = 1e-18
print @cksm[capacitance] @cks1[capacitance] @cks2[capacitance] @ccavm[capacitance] @ccav1[capacitance] @ccav2[capacitance]
tran 1e-05 17.5 0 1e-05
wrdata mnorele_20_iii$d v(mainjack) v(fixjack1) v(fixjack2)
wrdata mnorele_20_iii_stati$d v(xls.xs) v(xlp.xs) v(dep) v(ina) v(vplus) v(vminus) v(main_a) v(mainc) v(fixc1) v(fixc2)
destroy all
echo "mnorele_20_iii,mnorele_20_iii.dat,rif,20,3.818,10,100k,1.0,8.5,17.5,1e-05,rif_seq,-,-,0.0,0," >> tb_v2_casopeggiore_manifest.csv
echo "rele_20_iii,mev_20_iii.dat,rele_contro_norele,20,3.818,10,100k,7.5,8.5,17.5,1e-05,evento,mnorele_20_iii,mnorele_20_iii,0.0,4,S_ins;S_rel" >> tb_v2_casopeggiore_manifest.csv
* ---- L29d2 4: mh01_lz_iii ----
alter vamp dc = 0
alter vfrq dc = 1000
alter rldm = 100k
alter rld1 = 100k
alter rld2 = 100k
alter vti dc = 1.0
alter vtr dc = 7.6
alter vtijk dc = 7.5
alter vtrjk dc = 7.6
alter vosa dc = 0
alter vosb dc = 0
alter vosf1 dc = 0
alter vosf2 dc = 0
alter ratth = 1m
alter rattb = 10k
alter rl1 = 845
alter cwire = 100p
alter vk1i dc = 1
alter vk1t dc = 1000.000000
alter vk5i dc = 1
alter vk5t dc = 1000.000000
alter vt1ri dc = 1
alter vt1rt dc = 1000.000000
alter vt1si dc = 0
alter vt1st dc = 1000.000000
alter vt2ri dc = 1
alter vt2rt dc = 1000.000000
alter vt2si dc = 0
alter vt2st dc = 1000.000000
alter vtijk dc = 1000.000000
alter vtrjk dc = 2000.000000
alter vksa dc = 7.500000
alter vksb dc = 7.601000
alter vkca dc = 7.501000
alter vkcb dc = 7.600000
alter vtiser dc = -10
alter vtrser dc = 1000
alter rbym = 1e12
alter rby1 = 1e12
alter rby2 = 1e12
alter rbcm = 220k
alter rbc1 = 470k
alter rbc2 = 470k
alter cksm = 0.1p
alter cks1 = 0.1p
alter cks2 = 0.1p
alter ccavm = 1e-18
alter ccav1 = 1e-18
alter ccav2 = 1e-18
print @cksm[capacitance] @cks1[capacitance] @cks2[capacitance] @ccavm[capacitance] @ccav1[capacitance] @ccav2[capacitance]
tran 1e-05 16.6 0 1e-05
wrdata mh01_lz_iii$d v(mainjack) v(fixjack1) v(fixjack2)
wrdata mh01_lz_iii_stati$d v(xls.xs) v(xlp.xs) v(dep) v(ina) v(vplus) v(vminus) v(main_a) v(mainc) v(fixc1) v(fixc2)
destroy all
echo "mh01_lz_iii,mh01_lz_iii.dat,l29d2_iii_h01,1000,0,10,100k,1.0,7.6,16.6,1e-05,evento,g10sempre_lz_iii,g10mai_lz_iii,6.5,4,A_ins;A_rel;B2" >> tb_v2_casopeggiore_manifest.csv
* ---- L29d2 4: mev_lz_iii ----
alter vamp dc = 0
alter vfrq dc = 1000
alter rldm = 100k
alter rld1 = 100k
alter rld2 = 100k
alter vti dc = 1.0
alter vtr dc = 8.5
alter vtijk dc = 7.5
alter vtrjk dc = 8.5
alter vosa dc = 0
alter vosb dc = 0
alter vosf1 dc = 0
alter vosf2 dc = 0
alter ratth = 1m
alter rattb = 10k
alter rl1 = 845
alter cwire = 100p
alter vk1i dc = 1
alter vk1t dc = 1000.000000
alter vk5i dc = 1
alter vk5t dc = 1000.000000
alter vt1ri dc = 1
alter vt1rt dc = 1000.000000
alter vt1si dc = 0
alter vt1st dc = 1000.000000
alter vt2ri dc = 1
alter vt2rt dc = 1000.000000
alter vt2si dc = 0
alter vt2st dc = 1000.000000
alter vtijk dc = 1000.000000
alter vtrjk dc = 2000.000000
alter vksa dc = 7.500000
alter vksb dc = 8.501000
alter vkca dc = 7.501000
alter vkcb dc = 8.500000
alter vtiser dc = -10
alter vtrser dc = 1000
alter rbym = 1e12
alter rby1 = 1e12
alter rby2 = 1e12
alter rbcm = 220k
alter rbc1 = 470k
alter rbc2 = 470k
alter cksm = 0.1p
alter cks1 = 0.1p
alter cks2 = 0.1p
alter ccavm = 1e-18
alter ccav1 = 1e-18
alter ccav2 = 1e-18
print @cksm[capacitance] @cks1[capacitance] @cks2[capacitance] @ccavm[capacitance] @ccav1[capacitance] @ccav2[capacitance]
tran 1e-05 17.5 0 1e-05
wrdata mev_lz_iii$d v(mainjack) v(fixjack1) v(fixjack2)
wrdata mev_lz_iii_stati$d v(xls.xs) v(xlp.xs) v(dep) v(ina) v(vplus) v(vminus) v(main_a) v(mainc) v(fixc1) v(fixc2)
destroy all
echo "mev_lz_iii,mev_lz_iii.dat,l29d2_iii_ev,1000,0,10,100k,1.0,8.5,17.5,1e-05,evento,g10sempre_lz_iii,g10mai_lz_iii,6.5,4,A_ins;A_rel;B2" >> tb_v2_casopeggiore_manifest.csv
* ---- L29d2 4: mh2_lz_iii ----
alter vamp dc = 0
alter vfrq dc = 1000
alter rldm = 100k
alter rld1 = 100k
alter rld2 = 100k
alter vti dc = 1.0
alter vtr dc = 9.5
alter vtijk dc = 7.5
alter vtrjk dc = 9.5
alter vosa dc = 0
alter vosb dc = 0
alter vosf1 dc = 0
alter vosf2 dc = 0
alter ratth = 1m
alter rattb = 10k
alter rl1 = 845
alter cwire = 100p
alter vk1i dc = 1
alter vk1t dc = 1000.000000
alter vk5i dc = 1
alter vk5t dc = 1000.000000
alter vt1ri dc = 1
alter vt1rt dc = 1000.000000
alter vt1si dc = 0
alter vt1st dc = 1000.000000
alter vt2ri dc = 1
alter vt2rt dc = 1000.000000
alter vt2si dc = 0
alter vt2st dc = 1000.000000
alter vtijk dc = 1000.000000
alter vtrjk dc = 2000.000000
alter vksa dc = 7.500000
alter vksb dc = 9.501000
alter vkca dc = 7.501000
alter vkcb dc = 9.500000
alter vtiser dc = -10
alter vtrser dc = 1000
alter rbym = 1e12
alter rby1 = 1e12
alter rby2 = 1e12
alter rbcm = 220k
alter rbc1 = 470k
alter rbc2 = 470k
alter cksm = 0.1p
alter cks1 = 0.1p
alter cks2 = 0.1p
alter ccavm = 1e-18
alter ccav1 = 1e-18
alter ccav2 = 1e-18
print @cksm[capacitance] @cks1[capacitance] @cks2[capacitance] @ccavm[capacitance] @ccav1[capacitance] @ccav2[capacitance]
tran 1e-05 18.5 0 1e-05
wrdata mh2_lz_iii$d v(mainjack) v(fixjack1) v(fixjack2)
wrdata mh2_lz_iii_stati$d v(xls.xs) v(xlp.xs) v(dep) v(ina) v(vplus) v(vminus) v(main_a) v(mainc) v(fixc1) v(fixc2)
destroy all
echo "mh2_lz_iii,mh2_lz_iii.dat,l29d2_iii_h2,1000,0,10,100k,1.0,9.5,18.5,1e-05,evento,g10sempre_lz_iii,g10mai_lz_iii,6.5,4,A_ins;A_rel;B2" >> tb_v2_casopeggiore_manifest.csv
* ---- L29d2 4: mh20_lz_iii ----
alter vamp dc = 0
alter vfrq dc = 1000
alter rldm = 100k
alter rld1 = 100k
alter rld2 = 100k
alter vti dc = 1.0
alter vtr dc = 27.5
alter vtijk dc = 7.5
alter vtrjk dc = 27.5
alter vosa dc = 0
alter vosb dc = 0
alter vosf1 dc = 0
alter vosf2 dc = 0
alter ratth = 1m
alter rattb = 10k
alter rl1 = 845
alter cwire = 100p
alter vk1i dc = 1
alter vk1t dc = 1000.000000
alter vk5i dc = 1
alter vk5t dc = 1000.000000
alter vt1ri dc = 1
alter vt1rt dc = 1000.000000
alter vt1si dc = 0
alter vt1st dc = 1000.000000
alter vt2ri dc = 1
alter vt2rt dc = 1000.000000
alter vt2si dc = 0
alter vt2st dc = 1000.000000
alter vtijk dc = 1000.000000
alter vtrjk dc = 2000.000000
alter vksa dc = 7.500000
alter vksb dc = 27.501000
alter vkca dc = 7.501000
alter vkcb dc = 27.500000
alter vtiser dc = -10
alter vtrser dc = 1000
alter rbym = 1e12
alter rby1 = 1e12
alter rby2 = 1e12
alter rbcm = 220k
alter rbc1 = 470k
alter rbc2 = 470k
alter cksm = 0.1p
alter cks1 = 0.1p
alter cks2 = 0.1p
alter ccavm = 1e-18
alter ccav1 = 1e-18
alter ccav2 = 1e-18
print @cksm[capacitance] @cks1[capacitance] @cks2[capacitance] @ccavm[capacitance] @ccav1[capacitance] @ccav2[capacitance]
tran 1e-05 36.5 0 1e-05
wrdata mh20_lz_iii$d v(mainjack) v(fixjack1) v(fixjack2)
wrdata mh20_lz_iii_stati$d v(xls.xs) v(xlp.xs) v(dep) v(ina) v(vplus) v(vminus) v(main_a) v(mainc) v(fixc1) v(fixc2)
destroy all
echo "mh20_lz_iii,mh20_lz_iii.dat,l29d2_iii_h20,1000,0,10,100k,1.0,27.5,36.5,1e-05,evento,g10sempre_lz_iii,g10mai_lz_iii,6.5,4,A_ins;A_rel;B2" >> tb_v2_casopeggiore_manifest.csv
alter vamp dc = 0
alter vfrq dc = 1000
alter rldm = 100k
alter rld1 = 100k
alter rld2 = 100k
alter vti dc = 1.0
alter vtr dc = 8.5
alter vtijk dc = 7.5
alter vtrjk dc = 8.5
alter vosa dc = 0
alter vosb dc = 0
alter vosf1 dc = 0
alter vosf2 dc = 0
alter ratth = 1m
alter rattb = 10k
alter rl1 = 845
alter cwire = 100p
alter vk1i dc = 1
alter vk1t dc = 1000.000000
alter vk5i dc = 1
alter vk5t dc = 1000.000000
alter vt1ri dc = 1
alter vt1rt dc = 1000.000000
alter vt1si dc = 0
alter vt1st dc = 1000.000000
alter vt2ri dc = 1
alter vt2rt dc = 1000.000000
alter vt2si dc = 0
alter vt2st dc = 1000.000000
alter vtijk dc = 1000.000000
alter vtrjk dc = 2000.000000
alter vksa dc = 7.500000
alter vksb dc = 8.501000
alter vkca dc = 7.501000
alter vkcb dc = 8.500000
alter vtiser dc = -10
alter vtrser dc = 1000
alter rbym = 1e12
alter rby1 = 1e12
alter rby2 = 1e12
alter rbcm = 220k
alter rbc1 = 470k
alter rbc2 = 470k
alter cksm = 0.1p
alter cks1 = 0.1p
alter cks2 = 0.1p
alter ccavm = 1e-18
alter ccav1 = 1e-18
alter ccav2 = 1e-18
print @cksm[capacitance] @cks1[capacitance] @cks2[capacitance] @ccavm[capacitance] @ccav1[capacitance] @ccav2[capacitance]
tran 7e-06 17.5 0 7e-06
wrdata mevp_lz_iii$d v(mainjack) v(fixjack1) v(fixjack2)
destroy all
echo "pav_mev_0_iii,mevp_lz_iii.dat,pavimento,1000,0,10,100k,1.0,1000,17.5,7e-06,pav_num,mev_lz_iii,-,0.0,0," >> tb_v2_casopeggiore_manifest.csv
echo "pav_mev_1_iii,mevp_lz_iii.dat,pavimento,1000,0,10,100k,7.5,1000,17.5,7e-06,pav_num,mev_lz_iii,-,0.0,0," >> tb_v2_casopeggiore_manifest.csv
echo "pav_mev_2_iii,mevp_lz_iii.dat,pavimento,1000,0,10,100k,8.5,1000,17.5,7e-06,pav_num,mev_lz_iii,-,0.0,0," >> tb_v2_casopeggiore_manifest.csv
* ---- L29d2 5: on_r10s_iii ----
alter vamp dc = 0
alter vfrq dc = 1000
alter rldm = 100k
alter rld1 = 100k
alter rld2 = 100k
alter vti dc = -100
alter vtr dc = 2.6
alter vtijk dc = -10
alter vtrjk dc = 2.6
alter vosa dc = 0
alter vosb dc = 0
alter vosf1 dc = 0
alter vosf2 dc = 0
alter ratth = 1m
alter rattb = 10k
alter rl1 = 845
alter cwire = 100p
alter vk1i dc = 1
alter vk1t dc = 1000.000000
alter vk5i dc = 1
alter vk5t dc = 1000.000000
alter vt1ri dc = 1
alter vt1rt dc = 1000.000000
alter vt1si dc = 0
alter vt1st dc = 1000.000000
alter vt2ri dc = 1
alter vt2rt dc = 1000.000000
alter vt2si dc = 0
alter vt2st dc = 1000.000000
alter vtijk dc = 1000.000000
alter vtrjk dc = 2000.000000
alter vksa dc = -10.000000
alter vksb dc = 2.601000
alter vkca dc = -9.999000
alter vkcb dc = 2.600000
alter vtiser dc = -10
alter vtrser dc = 1000
alter rbym = 1e12
alter rby1 = 1e12
alter rby2 = 1e12
alter rbcm = 220k
alter rbc1 = 470k
alter rbc2 = 470k
alter cksm = 0.1p
alter cks1 = 0.1p
alter cks2 = 0.1p
alter ccavm = 1e-18
alter ccav1 = 1e-18
alter ccav2 = 1e-18
print @cksm[capacitance] @cks1[capacitance] @cks2[capacitance] @ccavm[capacitance] @ccav1[capacitance] @ccav2[capacitance]
alter @vpp[pwl] = [ 0 0 0.1 0 0.11 15 1000 15 ]
alter @vmm[pwl] = [ 0 0 0.1 0 0.11 -15 1000 -15 ]
alter @vpwl[pwl] = [ 0 0 0.1 0 0.11 1 1000 1 ]
tran 1e-05 11.6 0 1e-05
wrdata on_r10s_iii$d v(mainjack) v(fixjack1) v(fixjack2)
wrdata on_r10s_iii_stati$d v(xls.xs) v(xlp.xs) v(dep) v(ina) v(vplus) v(vminus) v(main_a) v(mainc) v(fixc1) v(fixc2)
destroy all
echo "on_r10s_iii,on_r10s_iii.dat,accensione_iii,1000,0,10,100k,0.1,2.6,11.6,1e-05,evento,g10sempre_lz_iii,g10mai_lz_iii,0.0,5,A_ins;A_rel" >> tb_v2_casopeggiore_manifest.csv
alter vamp dc = 0
alter vfrq dc = 1000
alter rldm = 100k
alter rld1 = 100k
alter rld2 = 100k
alter vti dc = 1000
alter vtr dc = 2000
alter vtijk dc = 1.0
alter vtrjk dc = 1000
alter vosa dc = 0
alter vosb dc = 0
alter vosf1 dc = 0
alter vosf2 dc = 0
alter ratth = 1m
alter rattb = 10k
alter rl1 = 845
alter cwire = 100p
alter vk1i dc = 1
alter vk1t dc = 1000.000000
alter vk5i dc = 1
alter vk5t dc = 1000.000000
alter vt1ri dc = 1
alter vt1rt dc = 1000.000000
alter vt1si dc = 0
alter vt1st dc = 1000.000000
alter vt2ri dc = 1
alter vt2rt dc = 1000.000000
alter vt2si dc = 0
alter vt2st dc = 1000.000000
alter vtijk dc = 1000.000000
alter vtrjk dc = 2000.000000
alter vksa dc = 1.000000
alter vksb dc = 1000.001000
alter vkca dc = 1.001000
alter vkcb dc = 1000.000000
alter vtiser dc = -10
alter vtrser dc = 1000
alter rbym = 1e12
alter rby1 = 1e12
alter rby2 = 1e12
alter rbcm = 220k
alter rbc1 = 470k
alter rbc2 = 470k
alter cksm = 0.1p
alter cks1 = 0.1p
alter cks2 = 0.1p
alter ccavm = 1e-18
alter ccav1 = 1e-18
alter ccav2 = 1e-18
print @cksm[capacitance] @cks1[capacitance] @cks2[capacitance] @ccavm[capacitance] @ccav1[capacitance] @ccav2[capacitance]
alter @vpp[pwl] = [ 0 15 1 15 1.01 1m 1000 1m ]
alter @vmm[pwl] = [ 0 -15 1 -15 1.01 -1m 1000 -1m ]
alter @vpwl[pwl] = [ 0 1 1 1 1.01 0 1000 0 ]
tran 1e-05 3.5 0 1e-05
wrdata off_r10s_d0_iii$d v(mainjack) v(fixjack1) v(fixjack2)
wrdata off_r10s_d0_iii_stati$d v(xls.xs) v(xlp.xs) v(dep) v(ina) v(vplus) v(vminus) v(main_a) v(mainc) v(fixc1) v(fixc2)
destroy all
echo "off_r10s_d0_iii,off_r10s_d0_iii.dat,spegnimento_iii,1000,0,10,100k,1.0,1000,3.5,1e-05,evento,g10sempre_lz_iii,-,0.0,5,A_ins" >> tb_v2_casopeggiore_manifest.csv
alter vamp dc = 0
alter vfrq dc = 1000
alter rldm = 100k
alter rld1 = 100k
alter rld2 = 100k
alter vti dc = 1000
alter vtr dc = 2000
alter vtijk dc = 1.005
alter vtrjk dc = 1000
alter vosa dc = 0
alter vosb dc = 0
alter vosf1 dc = 0
alter vosf2 dc = 0
alter ratth = 1m
alter rattb = 10k
alter rl1 = 845
alter cwire = 100p
alter vk1i dc = 1
alter vk1t dc = 1000.000000
alter vk5i dc = 1
alter vk5t dc = 1000.000000
alter vt1ri dc = 1
alter vt1rt dc = 1000.000000
alter vt1si dc = 0
alter vt1st dc = 1000.000000
alter vt2ri dc = 1
alter vt2rt dc = 1000.000000
alter vt2si dc = 0
alter vt2st dc = 1000.000000
alter vtijk dc = 1000.000000
alter vtrjk dc = 2000.000000
alter vksa dc = 1.005000
alter vksb dc = 1000.001000
alter vkca dc = 1.006000
alter vkcb dc = 1000.000000
alter vtiser dc = -10
alter vtrser dc = 1000
alter rbym = 1e12
alter rby1 = 1e12
alter rby2 = 1e12
alter rbcm = 220k
alter rbc1 = 470k
alter rbc2 = 470k
alter cksm = 0.1p
alter cks1 = 0.1p
alter cks2 = 0.1p
alter ccavm = 1e-18
alter ccav1 = 1e-18
alter ccav2 = 1e-18
print @cksm[capacitance] @cks1[capacitance] @cks2[capacitance] @ccavm[capacitance] @ccav1[capacitance] @ccav2[capacitance]
alter @vpp[pwl] = [ 0 15 1 15 1.01 1m 1000 1m ]
alter @vmm[pwl] = [ 0 -15 1 -15 1.01 -1m 1000 -1m ]
alter @vpwl[pwl] = [ 0 1 1 1 1.01 0 1000 0 ]
tran 1e-05 3.5 0 1e-05
wrdata off_r10s_d5_iii$d v(mainjack) v(fixjack1) v(fixjack2)
wrdata off_r10s_d5_iii_stati$d v(xls.xs) v(xlp.xs) v(dep) v(ina) v(vplus) v(vminus) v(main_a) v(mainc) v(fixc1) v(fixc2)
destroy all
echo "off_r10s_d5_iii,off_r10s_d5_iii.dat,spegnimento_iii,1000,0,10,100k,1.0,1000,3.5,1e-05,evento,g10sempre_lz_iii,-,0.0,5,A_ins" >> tb_v2_casopeggiore_manifest.csv
alter vamp dc = 0
alter vfrq dc = 1000
alter rldm = 100k
alter rld1 = 100k
alter rld2 = 100k
alter vti dc = 1000
alter vtr dc = 2000
alter vtijk dc = 1.02
alter vtrjk dc = 1000
alter vosa dc = 0
alter vosb dc = 0
alter vosf1 dc = 0
alter vosf2 dc = 0
alter ratth = 1m
alter rattb = 10k
alter rl1 = 845
alter cwire = 100p
alter vk1i dc = 1
alter vk1t dc = 1000.000000
alter vk5i dc = 1
alter vk5t dc = 1000.000000
alter vt1ri dc = 1
alter vt1rt dc = 1000.000000
alter vt1si dc = 0
alter vt1st dc = 1000.000000
alter vt2ri dc = 1
alter vt2rt dc = 1000.000000
alter vt2si dc = 0
alter vt2st dc = 1000.000000
alter vtijk dc = 1000.000000
alter vtrjk dc = 2000.000000
alter vksa dc = 1.020000
alter vksb dc = 1000.001000
alter vkca dc = 1.021000
alter vkcb dc = 1000.000000
alter vtiser dc = -10
alter vtrser dc = 1000
alter rbym = 1e12
alter rby1 = 1e12
alter rby2 = 1e12
alter rbcm = 220k
alter rbc1 = 470k
alter rbc2 = 470k
alter cksm = 0.1p
alter cks1 = 0.1p
alter cks2 = 0.1p
alter ccavm = 1e-18
alter ccav1 = 1e-18
alter ccav2 = 1e-18
print @cksm[capacitance] @cks1[capacitance] @cks2[capacitance] @ccavm[capacitance] @ccav1[capacitance] @ccav2[capacitance]
alter @vpp[pwl] = [ 0 15 1 15 1.01 1m 1000 1m ]
alter @vmm[pwl] = [ 0 -15 1 -15 1.01 -1m 1000 -1m ]
alter @vpwl[pwl] = [ 0 1 1 1 1.01 0 1000 0 ]
tran 1e-05 3.5 0 1e-05
wrdata off_r10s_d20_iii$d v(mainjack) v(fixjack1) v(fixjack2)
wrdata off_r10s_d20_iii_stati$d v(xls.xs) v(xlp.xs) v(dep) v(ina) v(vplus) v(vminus) v(main_a) v(mainc) v(fixc1) v(fixc2)
destroy all
echo "off_r10s_d20_iii,off_r10s_d20_iii.dat,spegnimento_iii,1000,0,10,100k,1.0,1000,3.5,1e-05,evento,g10sempre_lz_iii,-,0.0,5,A_ins" >> tb_v2_casopeggiore_manifest.csv
alter vamp dc = 0
alter vfrq dc = 1000
alter rldm = 100k
alter rld1 = 100k
alter rld2 = 100k
alter vti dc = 1000
alter vtr dc = 2000
alter vtijk dc = 1.1
alter vtrjk dc = 1000
alter vosa dc = 0
alter vosb dc = 0
alter vosf1 dc = 0
alter vosf2 dc = 0
alter ratth = 1m
alter rattb = 10k
alter rl1 = 845
alter cwire = 100p
alter vk1i dc = 1
alter vk1t dc = 1000.000000
alter vk5i dc = 1
alter vk5t dc = 1000.000000
alter vt1ri dc = 1
alter vt1rt dc = 1000.000000
alter vt1si dc = 0
alter vt1st dc = 1000.000000
alter vt2ri dc = 1
alter vt2rt dc = 1000.000000
alter vt2si dc = 0
alter vt2st dc = 1000.000000
alter vtijk dc = 1000.000000
alter vtrjk dc = 2000.000000
alter vksa dc = 1.100000
alter vksb dc = 1000.001000
alter vkca dc = 1.101000
alter vkcb dc = 1000.000000
alter vtiser dc = -10
alter vtrser dc = 1000
alter rbym = 1e12
alter rby1 = 1e12
alter rby2 = 1e12
alter rbcm = 220k
alter rbc1 = 470k
alter rbc2 = 470k
alter cksm = 0.1p
alter cks1 = 0.1p
alter cks2 = 0.1p
alter ccavm = 1e-18
alter ccav1 = 1e-18
alter ccav2 = 1e-18
print @cksm[capacitance] @cks1[capacitance] @cks2[capacitance] @ccavm[capacitance] @ccav1[capacitance] @ccav2[capacitance]
alter @vpp[pwl] = [ 0 15 1 15 1.01 1m 1000 1m ]
alter @vmm[pwl] = [ 0 -15 1 -15 1.01 -1m 1000 -1m ]
alter @vpwl[pwl] = [ 0 1 1 1 1.01 0 1000 0 ]
tran 1e-05 3.5 0 1e-05
wrdata off_r10s_d100_iii$d v(mainjack) v(fixjack1) v(fixjack2)
wrdata off_r10s_d100_iii_stati$d v(xls.xs) v(xlp.xs) v(dep) v(ina) v(vplus) v(vminus) v(main_a) v(mainc) v(fixc1) v(fixc2)
destroy all
echo "off_r10s_d100_iii,off_r10s_d100_iii.dat,spegnimento_iii,1000,0,10,100k,1.0,1000,3.5,1e-05,evento,g10sempre_lz_iii,-,0.0,5,A_ins" >> tb_v2_casopeggiore_manifest.csv
* ---- L29d2 5: on_r10p_iii ----
alter vamp dc = 0
alter vfrq dc = 1000
alter rldm = 100k
alter rld1 = 100k
alter rld2 = 100k
alter vti dc = -100
alter vtr dc = 2.6
alter vtijk dc = -10
alter vtrjk dc = 2.6
alter vosa dc = 0
alter vosb dc = 0
alter vosf1 dc = 0
alter vosf2 dc = 0
alter ratth = 1m
alter rattb = 10k
alter rl1 = 845
alter cwire = 100p
alter vk1i dc = 1
alter vk1t dc = 1000.000000
alter vk5i dc = 1
alter vk5t dc = 1000.000000
alter vt1ri dc = 1
alter vt1rt dc = 1000.000000
alter vt1si dc = 0
alter vt1st dc = 1000.000000
alter vt2ri dc = 1
alter vt2rt dc = 1000.000000
alter vt2si dc = 0
alter vt2st dc = 1000.000000
alter vtijk dc = 1000.000000
alter vtrjk dc = 2000.000000
alter vksa dc = -10.000000
alter vksb dc = 2.601000
alter vkca dc = -9.999000
alter vkcb dc = 2.600000
alter vtiser dc = -10
alter vtrser dc = 1000
alter rbym = 1e12
alter rby1 = 1e12
alter rby2 = 1e12
alter rbcm = 220k
alter rbc1 = 470k
alter rbc2 = 470k
alter cksm = 0.1p
alter cks1 = 0.1p
alter cks2 = 0.1p
alter ccavm = 1e-18
alter ccav1 = 1e-18
alter ccav2 = 1e-18
print @cksm[capacitance] @cks1[capacitance] @cks2[capacitance] @ccavm[capacitance] @ccav1[capacitance] @ccav2[capacitance]
alter @vpp[pwl] = [ 0 0 0.15 0 0.16 15 1000 15 ]
alter @vmm[pwl] = [ 0 0 0.1 0 0.11 -15 1000 -15 ]
alter @vpwl[pwl] = [ 0 0 0.15 0 0.16 1 1000 1 ]
tran 1e-05 11.6 0 1e-05
wrdata on_r10p_iii$d v(mainjack) v(fixjack1) v(fixjack2)
wrdata on_r10p_iii_stati$d v(xls.xs) v(xlp.xs) v(dep) v(ina) v(vplus) v(vminus) v(main_a) v(mainc) v(fixc1) v(fixc2)
destroy all
echo "on_r10p_iii,on_r10p_iii.dat,accensione_iii,1000,0,10,100k,0.1,2.6,11.6,1e-05,evento,g10sempre_lz_iii,g10mai_lz_iii,0.0,5,A_ins;A_rel" >> tb_v2_casopeggiore_manifest.csv
alter vamp dc = 0
alter vfrq dc = 1000
alter rldm = 100k
alter rld1 = 100k
alter rld2 = 100k
alter vti dc = 1000
alter vtr dc = 2000
alter vtijk dc = 1.0
alter vtrjk dc = 1000
alter vosa dc = 0
alter vosb dc = 0
alter vosf1 dc = 0
alter vosf2 dc = 0
alter ratth = 1m
alter rattb = 10k
alter rl1 = 845
alter cwire = 100p
alter vk1i dc = 1
alter vk1t dc = 1000.000000
alter vk5i dc = 1
alter vk5t dc = 1000.000000
alter vt1ri dc = 1
alter vt1rt dc = 1000.000000
alter vt1si dc = 0
alter vt1st dc = 1000.000000
alter vt2ri dc = 1
alter vt2rt dc = 1000.000000
alter vt2si dc = 0
alter vt2st dc = 1000.000000
alter vtijk dc = 1000.000000
alter vtrjk dc = 2000.000000
alter vksa dc = 1.000000
alter vksb dc = 1000.001000
alter vkca dc = 1.001000
alter vkcb dc = 1000.000000
alter vtiser dc = -10
alter vtrser dc = 1000
alter rbym = 1e12
alter rby1 = 1e12
alter rby2 = 1e12
alter rbcm = 220k
alter rbc1 = 470k
alter rbc2 = 470k
alter cksm = 0.1p
alter cks1 = 0.1p
alter cks2 = 0.1p
alter ccavm = 1e-18
alter ccav1 = 1e-18
alter ccav2 = 1e-18
print @cksm[capacitance] @cks1[capacitance] @cks2[capacitance] @ccavm[capacitance] @ccav1[capacitance] @ccav2[capacitance]
alter @vpp[pwl] = [ 0 15 1.05 15 1.06 1m 1000 1m ]
alter @vmm[pwl] = [ 0 -15 1 -15 1.01 -1m 1000 -1m ]
alter @vpwl[pwl] = [ 0 1 1.05 1 1.06 0 1000 0 ]
tran 1e-05 3.5 0 1e-05
wrdata off_r10p_d0_iii$d v(mainjack) v(fixjack1) v(fixjack2)
wrdata off_r10p_d0_iii_stati$d v(xls.xs) v(xlp.xs) v(dep) v(ina) v(vplus) v(vminus) v(main_a) v(mainc) v(fixc1) v(fixc2)
destroy all
echo "off_r10p_d0_iii,off_r10p_d0_iii.dat,spegnimento_iii,1000,0,10,100k,1.0,1000,3.5,1e-05,evento,g10sempre_lz_iii,-,0.0,5,A_ins" >> tb_v2_casopeggiore_manifest.csv
alter vamp dc = 0
alter vfrq dc = 1000
alter rldm = 100k
alter rld1 = 100k
alter rld2 = 100k
alter vti dc = 1000
alter vtr dc = 2000
alter vtijk dc = 1.005
alter vtrjk dc = 1000
alter vosa dc = 0
alter vosb dc = 0
alter vosf1 dc = 0
alter vosf2 dc = 0
alter ratth = 1m
alter rattb = 10k
alter rl1 = 845
alter cwire = 100p
alter vk1i dc = 1
alter vk1t dc = 1000.000000
alter vk5i dc = 1
alter vk5t dc = 1000.000000
alter vt1ri dc = 1
alter vt1rt dc = 1000.000000
alter vt1si dc = 0
alter vt1st dc = 1000.000000
alter vt2ri dc = 1
alter vt2rt dc = 1000.000000
alter vt2si dc = 0
alter vt2st dc = 1000.000000
alter vtijk dc = 1000.000000
alter vtrjk dc = 2000.000000
alter vksa dc = 1.005000
alter vksb dc = 1000.001000
alter vkca dc = 1.006000
alter vkcb dc = 1000.000000
alter vtiser dc = -10
alter vtrser dc = 1000
alter rbym = 1e12
alter rby1 = 1e12
alter rby2 = 1e12
alter rbcm = 220k
alter rbc1 = 470k
alter rbc2 = 470k
alter cksm = 0.1p
alter cks1 = 0.1p
alter cks2 = 0.1p
alter ccavm = 1e-18
alter ccav1 = 1e-18
alter ccav2 = 1e-18
print @cksm[capacitance] @cks1[capacitance] @cks2[capacitance] @ccavm[capacitance] @ccav1[capacitance] @ccav2[capacitance]
alter @vpp[pwl] = [ 0 15 1.05 15 1.06 1m 1000 1m ]
alter @vmm[pwl] = [ 0 -15 1 -15 1.01 -1m 1000 -1m ]
alter @vpwl[pwl] = [ 0 1 1.05 1 1.06 0 1000 0 ]
tran 1e-05 3.5 0 1e-05
wrdata off_r10p_d5_iii$d v(mainjack) v(fixjack1) v(fixjack2)
wrdata off_r10p_d5_iii_stati$d v(xls.xs) v(xlp.xs) v(dep) v(ina) v(vplus) v(vminus) v(main_a) v(mainc) v(fixc1) v(fixc2)
destroy all
echo "off_r10p_d5_iii,off_r10p_d5_iii.dat,spegnimento_iii,1000,0,10,100k,1.0,1000,3.5,1e-05,evento,g10sempre_lz_iii,-,0.0,5,A_ins" >> tb_v2_casopeggiore_manifest.csv
alter vamp dc = 0
alter vfrq dc = 1000
alter rldm = 100k
alter rld1 = 100k
alter rld2 = 100k
alter vti dc = 1000
alter vtr dc = 2000
alter vtijk dc = 1.02
alter vtrjk dc = 1000
alter vosa dc = 0
alter vosb dc = 0
alter vosf1 dc = 0
alter vosf2 dc = 0
alter ratth = 1m
alter rattb = 10k
alter rl1 = 845
alter cwire = 100p
alter vk1i dc = 1
alter vk1t dc = 1000.000000
alter vk5i dc = 1
alter vk5t dc = 1000.000000
alter vt1ri dc = 1
alter vt1rt dc = 1000.000000
alter vt1si dc = 0
alter vt1st dc = 1000.000000
alter vt2ri dc = 1
alter vt2rt dc = 1000.000000
alter vt2si dc = 0
alter vt2st dc = 1000.000000
alter vtijk dc = 1000.000000
alter vtrjk dc = 2000.000000
alter vksa dc = 1.020000
alter vksb dc = 1000.001000
alter vkca dc = 1.021000
alter vkcb dc = 1000.000000
alter vtiser dc = -10
alter vtrser dc = 1000
alter rbym = 1e12
alter rby1 = 1e12
alter rby2 = 1e12
alter rbcm = 220k
alter rbc1 = 470k
alter rbc2 = 470k
alter cksm = 0.1p
alter cks1 = 0.1p
alter cks2 = 0.1p
alter ccavm = 1e-18
alter ccav1 = 1e-18
alter ccav2 = 1e-18
print @cksm[capacitance] @cks1[capacitance] @cks2[capacitance] @ccavm[capacitance] @ccav1[capacitance] @ccav2[capacitance]
alter @vpp[pwl] = [ 0 15 1.05 15 1.06 1m 1000 1m ]
alter @vmm[pwl] = [ 0 -15 1 -15 1.01 -1m 1000 -1m ]
alter @vpwl[pwl] = [ 0 1 1.05 1 1.06 0 1000 0 ]
tran 1e-05 3.5 0 1e-05
wrdata off_r10p_d20_iii$d v(mainjack) v(fixjack1) v(fixjack2)
wrdata off_r10p_d20_iii_stati$d v(xls.xs) v(xlp.xs) v(dep) v(ina) v(vplus) v(vminus) v(main_a) v(mainc) v(fixc1) v(fixc2)
destroy all
echo "off_r10p_d20_iii,off_r10p_d20_iii.dat,spegnimento_iii,1000,0,10,100k,1.0,1000,3.5,1e-05,evento,g10sempre_lz_iii,-,0.0,5,A_ins" >> tb_v2_casopeggiore_manifest.csv
alter vamp dc = 0
alter vfrq dc = 1000
alter rldm = 100k
alter rld1 = 100k
alter rld2 = 100k
alter vti dc = 1000
alter vtr dc = 2000
alter vtijk dc = 1.1
alter vtrjk dc = 1000
alter vosa dc = 0
alter vosb dc = 0
alter vosf1 dc = 0
alter vosf2 dc = 0
alter ratth = 1m
alter rattb = 10k
alter rl1 = 845
alter cwire = 100p
alter vk1i dc = 1
alter vk1t dc = 1000.000000
alter vk5i dc = 1
alter vk5t dc = 1000.000000
alter vt1ri dc = 1
alter vt1rt dc = 1000.000000
alter vt1si dc = 0
alter vt1st dc = 1000.000000
alter vt2ri dc = 1
alter vt2rt dc = 1000.000000
alter vt2si dc = 0
alter vt2st dc = 1000.000000
alter vtijk dc = 1000.000000
alter vtrjk dc = 2000.000000
alter vksa dc = 1.100000
alter vksb dc = 1000.001000
alter vkca dc = 1.101000
alter vkcb dc = 1000.000000
alter vtiser dc = -10
alter vtrser dc = 1000
alter rbym = 1e12
alter rby1 = 1e12
alter rby2 = 1e12
alter rbcm = 220k
alter rbc1 = 470k
alter rbc2 = 470k
alter cksm = 0.1p
alter cks1 = 0.1p
alter cks2 = 0.1p
alter ccavm = 1e-18
alter ccav1 = 1e-18
alter ccav2 = 1e-18
print @cksm[capacitance] @cks1[capacitance] @cks2[capacitance] @ccavm[capacitance] @ccav1[capacitance] @ccav2[capacitance]
alter @vpp[pwl] = [ 0 15 1.05 15 1.06 1m 1000 1m ]
alter @vmm[pwl] = [ 0 -15 1 -15 1.01 -1m 1000 -1m ]
alter @vpwl[pwl] = [ 0 1 1.05 1 1.06 0 1000 0 ]
tran 1e-05 3.5 0 1e-05
wrdata off_r10p_d100_iii$d v(mainjack) v(fixjack1) v(fixjack2)
wrdata off_r10p_d100_iii_stati$d v(xls.xs) v(xlp.xs) v(dep) v(ina) v(vplus) v(vminus) v(main_a) v(mainc) v(fixc1) v(fixc2)
destroy all
echo "off_r10p_d100_iii,off_r10p_d100_iii.dat,spegnimento_iii,1000,0,10,100k,1.0,1000,3.5,1e-05,evento,g10sempre_lz_iii,-,0.0,5,A_ins" >> tb_v2_casopeggiore_manifest.csv
* ---- L29d2 5: on_r10m_iii ----
alter vamp dc = 0
alter vfrq dc = 1000
alter rldm = 100k
alter rld1 = 100k
alter rld2 = 100k
alter vti dc = -100
alter vtr dc = 2.6
alter vtijk dc = -10
alter vtrjk dc = 2.6
alter vosa dc = 0
alter vosb dc = 0
alter vosf1 dc = 0
alter vosf2 dc = 0
alter ratth = 1m
alter rattb = 10k
alter rl1 = 845
alter cwire = 100p
alter vk1i dc = 1
alter vk1t dc = 1000.000000
alter vk5i dc = 1
alter vk5t dc = 1000.000000
alter vt1ri dc = 1
alter vt1rt dc = 1000.000000
alter vt1si dc = 0
alter vt1st dc = 1000.000000
alter vt2ri dc = 1
alter vt2rt dc = 1000.000000
alter vt2si dc = 0
alter vt2st dc = 1000.000000
alter vtijk dc = 1000.000000
alter vtrjk dc = 2000.000000
alter vksa dc = -10.000000
alter vksb dc = 2.601000
alter vkca dc = -9.999000
alter vkcb dc = 2.600000
alter vtiser dc = -10
alter vtrser dc = 1000
alter rbym = 1e12
alter rby1 = 1e12
alter rby2 = 1e12
alter rbcm = 220k
alter rbc1 = 470k
alter rbc2 = 470k
alter cksm = 0.1p
alter cks1 = 0.1p
alter cks2 = 0.1p
alter ccavm = 1e-18
alter ccav1 = 1e-18
alter ccav2 = 1e-18
print @cksm[capacitance] @cks1[capacitance] @cks2[capacitance] @ccavm[capacitance] @ccav1[capacitance] @ccav2[capacitance]
alter @vpp[pwl] = [ 0 0 0.1 0 0.11 15 1000 15 ]
alter @vmm[pwl] = [ 0 0 0.15 0 0.16 -15 1000 -15 ]
alter @vpwl[pwl] = [ 0 0 0.1 0 0.11 1 1000 1 ]
tran 1e-05 11.6 0 1e-05
wrdata on_r10m_iii$d v(mainjack) v(fixjack1) v(fixjack2)
wrdata on_r10m_iii_stati$d v(xls.xs) v(xlp.xs) v(dep) v(ina) v(vplus) v(vminus) v(main_a) v(mainc) v(fixc1) v(fixc2)
destroy all
echo "on_r10m_iii,on_r10m_iii.dat,accensione_iii,1000,0,10,100k,0.1,2.6,11.6,1e-05,evento,g10sempre_lz_iii,g10mai_lz_iii,0.0,5,A_ins;A_rel" >> tb_v2_casopeggiore_manifest.csv
alter vamp dc = 0
alter vfrq dc = 1000
alter rldm = 100k
alter rld1 = 100k
alter rld2 = 100k
alter vti dc = 1000
alter vtr dc = 2000
alter vtijk dc = 1.0
alter vtrjk dc = 1000
alter vosa dc = 0
alter vosb dc = 0
alter vosf1 dc = 0
alter vosf2 dc = 0
alter ratth = 1m
alter rattb = 10k
alter rl1 = 845
alter cwire = 100p
alter vk1i dc = 1
alter vk1t dc = 1000.000000
alter vk5i dc = 1
alter vk5t dc = 1000.000000
alter vt1ri dc = 1
alter vt1rt dc = 1000.000000
alter vt1si dc = 0
alter vt1st dc = 1000.000000
alter vt2ri dc = 1
alter vt2rt dc = 1000.000000
alter vt2si dc = 0
alter vt2st dc = 1000.000000
alter vtijk dc = 1000.000000
alter vtrjk dc = 2000.000000
alter vksa dc = 1.000000
alter vksb dc = 1000.001000
alter vkca dc = 1.001000
alter vkcb dc = 1000.000000
alter vtiser dc = -10
alter vtrser dc = 1000
alter rbym = 1e12
alter rby1 = 1e12
alter rby2 = 1e12
alter rbcm = 220k
alter rbc1 = 470k
alter rbc2 = 470k
alter cksm = 0.1p
alter cks1 = 0.1p
alter cks2 = 0.1p
alter ccavm = 1e-18
alter ccav1 = 1e-18
alter ccav2 = 1e-18
print @cksm[capacitance] @cks1[capacitance] @cks2[capacitance] @ccavm[capacitance] @ccav1[capacitance] @ccav2[capacitance]
alter @vpp[pwl] = [ 0 15 1 15 1.01 1m 1000 1m ]
alter @vmm[pwl] = [ 0 -15 1.05 -15 1.06 -1m 1000 -1m ]
alter @vpwl[pwl] = [ 0 1 1 1 1.01 0 1000 0 ]
tran 1e-05 3.5 0 1e-05
wrdata off_r10m_d0_iii$d v(mainjack) v(fixjack1) v(fixjack2)
wrdata off_r10m_d0_iii_stati$d v(xls.xs) v(xlp.xs) v(dep) v(ina) v(vplus) v(vminus) v(main_a) v(mainc) v(fixc1) v(fixc2)
destroy all
echo "off_r10m_d0_iii,off_r10m_d0_iii.dat,spegnimento_iii,1000,0,10,100k,1.0,1000,3.5,1e-05,evento,g10sempre_lz_iii,-,0.0,5,A_ins" >> tb_v2_casopeggiore_manifest.csv
alter vamp dc = 0
alter vfrq dc = 1000
alter rldm = 100k
alter rld1 = 100k
alter rld2 = 100k
alter vti dc = 1000
alter vtr dc = 2000
alter vtijk dc = 1.005
alter vtrjk dc = 1000
alter vosa dc = 0
alter vosb dc = 0
alter vosf1 dc = 0
alter vosf2 dc = 0
alter ratth = 1m
alter rattb = 10k
alter rl1 = 845
alter cwire = 100p
alter vk1i dc = 1
alter vk1t dc = 1000.000000
alter vk5i dc = 1
alter vk5t dc = 1000.000000
alter vt1ri dc = 1
alter vt1rt dc = 1000.000000
alter vt1si dc = 0
alter vt1st dc = 1000.000000
alter vt2ri dc = 1
alter vt2rt dc = 1000.000000
alter vt2si dc = 0
alter vt2st dc = 1000.000000
alter vtijk dc = 1000.000000
alter vtrjk dc = 2000.000000
alter vksa dc = 1.005000
alter vksb dc = 1000.001000
alter vkca dc = 1.006000
alter vkcb dc = 1000.000000
alter vtiser dc = -10
alter vtrser dc = 1000
alter rbym = 1e12
alter rby1 = 1e12
alter rby2 = 1e12
alter rbcm = 220k
alter rbc1 = 470k
alter rbc2 = 470k
alter cksm = 0.1p
alter cks1 = 0.1p
alter cks2 = 0.1p
alter ccavm = 1e-18
alter ccav1 = 1e-18
alter ccav2 = 1e-18
print @cksm[capacitance] @cks1[capacitance] @cks2[capacitance] @ccavm[capacitance] @ccav1[capacitance] @ccav2[capacitance]
alter @vpp[pwl] = [ 0 15 1 15 1.01 1m 1000 1m ]
alter @vmm[pwl] = [ 0 -15 1.05 -15 1.06 -1m 1000 -1m ]
alter @vpwl[pwl] = [ 0 1 1 1 1.01 0 1000 0 ]
tran 1e-05 3.5 0 1e-05
wrdata off_r10m_d5_iii$d v(mainjack) v(fixjack1) v(fixjack2)
wrdata off_r10m_d5_iii_stati$d v(xls.xs) v(xlp.xs) v(dep) v(ina) v(vplus) v(vminus) v(main_a) v(mainc) v(fixc1) v(fixc2)
destroy all
echo "off_r10m_d5_iii,off_r10m_d5_iii.dat,spegnimento_iii,1000,0,10,100k,1.0,1000,3.5,1e-05,evento,g10sempre_lz_iii,-,0.0,5,A_ins" >> tb_v2_casopeggiore_manifest.csv
alter vamp dc = 0
alter vfrq dc = 1000
alter rldm = 100k
alter rld1 = 100k
alter rld2 = 100k
alter vti dc = 1000
alter vtr dc = 2000
alter vtijk dc = 1.02
alter vtrjk dc = 1000
alter vosa dc = 0
alter vosb dc = 0
alter vosf1 dc = 0
alter vosf2 dc = 0
alter ratth = 1m
alter rattb = 10k
alter rl1 = 845
alter cwire = 100p
alter vk1i dc = 1
alter vk1t dc = 1000.000000
alter vk5i dc = 1
alter vk5t dc = 1000.000000
alter vt1ri dc = 1
alter vt1rt dc = 1000.000000
alter vt1si dc = 0
alter vt1st dc = 1000.000000
alter vt2ri dc = 1
alter vt2rt dc = 1000.000000
alter vt2si dc = 0
alter vt2st dc = 1000.000000
alter vtijk dc = 1000.000000
alter vtrjk dc = 2000.000000
alter vksa dc = 1.020000
alter vksb dc = 1000.001000
alter vkca dc = 1.021000
alter vkcb dc = 1000.000000
alter vtiser dc = -10
alter vtrser dc = 1000
alter rbym = 1e12
alter rby1 = 1e12
alter rby2 = 1e12
alter rbcm = 220k
alter rbc1 = 470k
alter rbc2 = 470k
alter cksm = 0.1p
alter cks1 = 0.1p
alter cks2 = 0.1p
alter ccavm = 1e-18
alter ccav1 = 1e-18
alter ccav2 = 1e-18
print @cksm[capacitance] @cks1[capacitance] @cks2[capacitance] @ccavm[capacitance] @ccav1[capacitance] @ccav2[capacitance]
alter @vpp[pwl] = [ 0 15 1 15 1.01 1m 1000 1m ]
alter @vmm[pwl] = [ 0 -15 1.05 -15 1.06 -1m 1000 -1m ]
alter @vpwl[pwl] = [ 0 1 1 1 1.01 0 1000 0 ]
tran 1e-05 3.5 0 1e-05
wrdata off_r10m_d20_iii$d v(mainjack) v(fixjack1) v(fixjack2)
wrdata off_r10m_d20_iii_stati$d v(xls.xs) v(xlp.xs) v(dep) v(ina) v(vplus) v(vminus) v(main_a) v(mainc) v(fixc1) v(fixc2)
destroy all
echo "off_r10m_d20_iii,off_r10m_d20_iii.dat,spegnimento_iii,1000,0,10,100k,1.0,1000,3.5,1e-05,evento,g10sempre_lz_iii,-,0.0,5,A_ins" >> tb_v2_casopeggiore_manifest.csv
alter vamp dc = 0
alter vfrq dc = 1000
alter rldm = 100k
alter rld1 = 100k
alter rld2 = 100k
alter vti dc = 1000
alter vtr dc = 2000
alter vtijk dc = 1.1
alter vtrjk dc = 1000
alter vosa dc = 0
alter vosb dc = 0
alter vosf1 dc = 0
alter vosf2 dc = 0
alter ratth = 1m
alter rattb = 10k
alter rl1 = 845
alter cwire = 100p
alter vk1i dc = 1
alter vk1t dc = 1000.000000
alter vk5i dc = 1
alter vk5t dc = 1000.000000
alter vt1ri dc = 1
alter vt1rt dc = 1000.000000
alter vt1si dc = 0
alter vt1st dc = 1000.000000
alter vt2ri dc = 1
alter vt2rt dc = 1000.000000
alter vt2si dc = 0
alter vt2st dc = 1000.000000
alter vtijk dc = 1000.000000
alter vtrjk dc = 2000.000000
alter vksa dc = 1.100000
alter vksb dc = 1000.001000
alter vkca dc = 1.101000
alter vkcb dc = 1000.000000
alter vtiser dc = -10
alter vtrser dc = 1000
alter rbym = 1e12
alter rby1 = 1e12
alter rby2 = 1e12
alter rbcm = 220k
alter rbc1 = 470k
alter rbc2 = 470k
alter cksm = 0.1p
alter cks1 = 0.1p
alter cks2 = 0.1p
alter ccavm = 1e-18
alter ccav1 = 1e-18
alter ccav2 = 1e-18
print @cksm[capacitance] @cks1[capacitance] @cks2[capacitance] @ccavm[capacitance] @ccav1[capacitance] @ccav2[capacitance]
alter @vpp[pwl] = [ 0 15 1 15 1.01 1m 1000 1m ]
alter @vmm[pwl] = [ 0 -15 1.05 -15 1.06 -1m 1000 -1m ]
alter @vpwl[pwl] = [ 0 1 1 1 1.01 0 1000 0 ]
tran 1e-05 3.5 0 1e-05
wrdata off_r10m_d100_iii$d v(mainjack) v(fixjack1) v(fixjack2)
wrdata off_r10m_d100_iii_stati$d v(xls.xs) v(xlp.xs) v(dep) v(ina) v(vplus) v(vminus) v(main_a) v(mainc) v(fixc1) v(fixc2)
destroy all
echo "off_r10m_d100_iii,off_r10m_d100_iii.dat,spegnimento_iii,1000,0,10,100k,1.0,1000,3.5,1e-05,evento,g10sempre_lz_iii,-,0.0,5,A_ins" >> tb_v2_casopeggiore_manifest.csv
* ---- L29d2 5: on_r300s_iii ----
alter vamp dc = 0
alter vfrq dc = 1000
alter rldm = 100k
alter rld1 = 100k
alter rld2 = 100k
alter vti dc = -100
alter vtr dc = 2.6
alter vtijk dc = -10
alter vtrjk dc = 2.6
alter vosa dc = 0
alter vosb dc = 0
alter vosf1 dc = 0
alter vosf2 dc = 0
alter ratth = 1m
alter rattb = 10k
alter rl1 = 845
alter cwire = 100p
alter vk1i dc = 1
alter vk1t dc = 1000.000000
alter vk5i dc = 1
alter vk5t dc = 1000.000000
alter vt1ri dc = 1
alter vt1rt dc = 1000.000000
alter vt1si dc = 0
alter vt1st dc = 1000.000000
alter vt2ri dc = 1
alter vt2rt dc = 1000.000000
alter vt2si dc = 0
alter vt2st dc = 1000.000000
alter vtijk dc = 1000.000000
alter vtrjk dc = 2000.000000
alter vksa dc = -10.000000
alter vksb dc = 2.601000
alter vkca dc = -9.999000
alter vkcb dc = 2.600000
alter vtiser dc = -10
alter vtrser dc = 1000
alter rbym = 1e12
alter rby1 = 1e12
alter rby2 = 1e12
alter rbcm = 220k
alter rbc1 = 470k
alter rbc2 = 470k
alter cksm = 0.1p
alter cks1 = 0.1p
alter cks2 = 0.1p
alter ccavm = 1e-18
alter ccav1 = 1e-18
alter ccav2 = 1e-18
print @cksm[capacitance] @cks1[capacitance] @cks2[capacitance] @ccavm[capacitance] @ccav1[capacitance] @ccav2[capacitance]
alter @vpp[pwl] = [ 0 0 0.1 0 0.4 15 1000 15 ]
alter @vmm[pwl] = [ 0 0 0.1 0 0.4 -15 1000 -15 ]
alter @vpwl[pwl] = [ 0 0 0.1 0 0.4 1 1000 1 ]
tran 1e-05 11.6 0 1e-05
wrdata on_r300s_iii$d v(mainjack) v(fixjack1) v(fixjack2)
wrdata on_r300s_iii_stati$d v(xls.xs) v(xlp.xs) v(dep) v(ina) v(vplus) v(vminus) v(main_a) v(mainc) v(fixc1) v(fixc2)
destroy all
echo "on_r300s_iii,on_r300s_iii.dat,accensione_iii,1000,0,10,100k,0.1,2.6,11.6,1e-05,evento,g10sempre_lz_iii,g10mai_lz_iii,0.0,5,A_ins;A_rel" >> tb_v2_casopeggiore_manifest.csv
alter vamp dc = 0
alter vfrq dc = 1000
alter rldm = 100k
alter rld1 = 100k
alter rld2 = 100k
alter vti dc = 1000
alter vtr dc = 2000
alter vtijk dc = 1.0
alter vtrjk dc = 1000
alter vosa dc = 0
alter vosb dc = 0
alter vosf1 dc = 0
alter vosf2 dc = 0
alter ratth = 1m
alter rattb = 10k
alter rl1 = 845
alter cwire = 100p
alter vk1i dc = 1
alter vk1t dc = 1000.000000
alter vk5i dc = 1
alter vk5t dc = 1000.000000
alter vt1ri dc = 1
alter vt1rt dc = 1000.000000
alter vt1si dc = 0
alter vt1st dc = 1000.000000
alter vt2ri dc = 1
alter vt2rt dc = 1000.000000
alter vt2si dc = 0
alter vt2st dc = 1000.000000
alter vtijk dc = 1000.000000
alter vtrjk dc = 2000.000000
alter vksa dc = 1.000000
alter vksb dc = 1000.001000
alter vkca dc = 1.001000
alter vkcb dc = 1000.000000
alter vtiser dc = -10
alter vtrser dc = 1000
alter rbym = 1e12
alter rby1 = 1e12
alter rby2 = 1e12
alter rbcm = 220k
alter rbc1 = 470k
alter rbc2 = 470k
alter cksm = 0.1p
alter cks1 = 0.1p
alter cks2 = 0.1p
alter ccavm = 1e-18
alter ccav1 = 1e-18
alter ccav2 = 1e-18
print @cksm[capacitance] @cks1[capacitance] @cks2[capacitance] @ccavm[capacitance] @ccav1[capacitance] @ccav2[capacitance]
alter @vpp[pwl] = [ 0 15 1 15 1.3 1m 1000 1m ]
alter @vmm[pwl] = [ 0 -15 1 -15 1.3 -1m 1000 -1m ]
alter @vpwl[pwl] = [ 0 1 1 1 1.3 0 1000 0 ]
tran 1e-05 3.5 0 1e-05
wrdata off_r300s_d0_iii$d v(mainjack) v(fixjack1) v(fixjack2)
wrdata off_r300s_d0_iii_stati$d v(xls.xs) v(xlp.xs) v(dep) v(ina) v(vplus) v(vminus) v(main_a) v(mainc) v(fixc1) v(fixc2)
destroy all
echo "off_r300s_d0_iii,off_r300s_d0_iii.dat,spegnimento_iii,1000,0,10,100k,1.0,1000,3.5,1e-05,evento,g10sempre_lz_iii,-,0.0,5,A_ins" >> tb_v2_casopeggiore_manifest.csv
alter vamp dc = 0
alter vfrq dc = 1000
alter rldm = 100k
alter rld1 = 100k
alter rld2 = 100k
alter vti dc = 1000
alter vtr dc = 2000
alter vtijk dc = 1.005
alter vtrjk dc = 1000
alter vosa dc = 0
alter vosb dc = 0
alter vosf1 dc = 0
alter vosf2 dc = 0
alter ratth = 1m
alter rattb = 10k
alter rl1 = 845
alter cwire = 100p
alter vk1i dc = 1
alter vk1t dc = 1000.000000
alter vk5i dc = 1
alter vk5t dc = 1000.000000
alter vt1ri dc = 1
alter vt1rt dc = 1000.000000
alter vt1si dc = 0
alter vt1st dc = 1000.000000
alter vt2ri dc = 1
alter vt2rt dc = 1000.000000
alter vt2si dc = 0
alter vt2st dc = 1000.000000
alter vtijk dc = 1000.000000
alter vtrjk dc = 2000.000000
alter vksa dc = 1.005000
alter vksb dc = 1000.001000
alter vkca dc = 1.006000
alter vkcb dc = 1000.000000
alter vtiser dc = -10
alter vtrser dc = 1000
alter rbym = 1e12
alter rby1 = 1e12
alter rby2 = 1e12
alter rbcm = 220k
alter rbc1 = 470k
alter rbc2 = 470k
alter cksm = 0.1p
alter cks1 = 0.1p
alter cks2 = 0.1p
alter ccavm = 1e-18
alter ccav1 = 1e-18
alter ccav2 = 1e-18
print @cksm[capacitance] @cks1[capacitance] @cks2[capacitance] @ccavm[capacitance] @ccav1[capacitance] @ccav2[capacitance]
alter @vpp[pwl] = [ 0 15 1 15 1.3 1m 1000 1m ]
alter @vmm[pwl] = [ 0 -15 1 -15 1.3 -1m 1000 -1m ]
alter @vpwl[pwl] = [ 0 1 1 1 1.3 0 1000 0 ]
tran 1e-05 3.5 0 1e-05
wrdata off_r300s_d5_iii$d v(mainjack) v(fixjack1) v(fixjack2)
wrdata off_r300s_d5_iii_stati$d v(xls.xs) v(xlp.xs) v(dep) v(ina) v(vplus) v(vminus) v(main_a) v(mainc) v(fixc1) v(fixc2)
destroy all
echo "off_r300s_d5_iii,off_r300s_d5_iii.dat,spegnimento_iii,1000,0,10,100k,1.0,1000,3.5,1e-05,evento,g10sempre_lz_iii,-,0.0,5,A_ins" >> tb_v2_casopeggiore_manifest.csv
alter vamp dc = 0
alter vfrq dc = 1000
alter rldm = 100k
alter rld1 = 100k
alter rld2 = 100k
alter vti dc = 1000
alter vtr dc = 2000
alter vtijk dc = 1.02
alter vtrjk dc = 1000
alter vosa dc = 0
alter vosb dc = 0
alter vosf1 dc = 0
alter vosf2 dc = 0
alter ratth = 1m
alter rattb = 10k
alter rl1 = 845
alter cwire = 100p
alter vk1i dc = 1
alter vk1t dc = 1000.000000
alter vk5i dc = 1
alter vk5t dc = 1000.000000
alter vt1ri dc = 1
alter vt1rt dc = 1000.000000
alter vt1si dc = 0
alter vt1st dc = 1000.000000
alter vt2ri dc = 1
alter vt2rt dc = 1000.000000
alter vt2si dc = 0
alter vt2st dc = 1000.000000
alter vtijk dc = 1000.000000
alter vtrjk dc = 2000.000000
alter vksa dc = 1.020000
alter vksb dc = 1000.001000
alter vkca dc = 1.021000
alter vkcb dc = 1000.000000
alter vtiser dc = -10
alter vtrser dc = 1000
alter rbym = 1e12
alter rby1 = 1e12
alter rby2 = 1e12
alter rbcm = 220k
alter rbc1 = 470k
alter rbc2 = 470k
alter cksm = 0.1p
alter cks1 = 0.1p
alter cks2 = 0.1p
alter ccavm = 1e-18
alter ccav1 = 1e-18
alter ccav2 = 1e-18
print @cksm[capacitance] @cks1[capacitance] @cks2[capacitance] @ccavm[capacitance] @ccav1[capacitance] @ccav2[capacitance]
alter @vpp[pwl] = [ 0 15 1 15 1.3 1m 1000 1m ]
alter @vmm[pwl] = [ 0 -15 1 -15 1.3 -1m 1000 -1m ]
alter @vpwl[pwl] = [ 0 1 1 1 1.3 0 1000 0 ]
tran 1e-05 3.5 0 1e-05
wrdata off_r300s_d20_iii$d v(mainjack) v(fixjack1) v(fixjack2)
wrdata off_r300s_d20_iii_stati$d v(xls.xs) v(xlp.xs) v(dep) v(ina) v(vplus) v(vminus) v(main_a) v(mainc) v(fixc1) v(fixc2)
destroy all
echo "off_r300s_d20_iii,off_r300s_d20_iii.dat,spegnimento_iii,1000,0,10,100k,1.0,1000,3.5,1e-05,evento,g10sempre_lz_iii,-,0.0,5,A_ins" >> tb_v2_casopeggiore_manifest.csv
alter vamp dc = 0
alter vfrq dc = 1000
alter rldm = 100k
alter rld1 = 100k
alter rld2 = 100k
alter vti dc = 1000
alter vtr dc = 2000
alter vtijk dc = 1.1
alter vtrjk dc = 1000
alter vosa dc = 0
alter vosb dc = 0
alter vosf1 dc = 0
alter vosf2 dc = 0
alter ratth = 1m
alter rattb = 10k
alter rl1 = 845
alter cwire = 100p
alter vk1i dc = 1
alter vk1t dc = 1000.000000
alter vk5i dc = 1
alter vk5t dc = 1000.000000
alter vt1ri dc = 1
alter vt1rt dc = 1000.000000
alter vt1si dc = 0
alter vt1st dc = 1000.000000
alter vt2ri dc = 1
alter vt2rt dc = 1000.000000
alter vt2si dc = 0
alter vt2st dc = 1000.000000
alter vtijk dc = 1000.000000
alter vtrjk dc = 2000.000000
alter vksa dc = 1.100000
alter vksb dc = 1000.001000
alter vkca dc = 1.101000
alter vkcb dc = 1000.000000
alter vtiser dc = -10
alter vtrser dc = 1000
alter rbym = 1e12
alter rby1 = 1e12
alter rby2 = 1e12
alter rbcm = 220k
alter rbc1 = 470k
alter rbc2 = 470k
alter cksm = 0.1p
alter cks1 = 0.1p
alter cks2 = 0.1p
alter ccavm = 1e-18
alter ccav1 = 1e-18
alter ccav2 = 1e-18
print @cksm[capacitance] @cks1[capacitance] @cks2[capacitance] @ccavm[capacitance] @ccav1[capacitance] @ccav2[capacitance]
alter @vpp[pwl] = [ 0 15 1 15 1.3 1m 1000 1m ]
alter @vmm[pwl] = [ 0 -15 1 -15 1.3 -1m 1000 -1m ]
alter @vpwl[pwl] = [ 0 1 1 1 1.3 0 1000 0 ]
tran 1e-05 3.5 0 1e-05
wrdata off_r300s_d100_iii$d v(mainjack) v(fixjack1) v(fixjack2)
wrdata off_r300s_d100_iii_stati$d v(xls.xs) v(xlp.xs) v(dep) v(ina) v(vplus) v(vminus) v(main_a) v(mainc) v(fixc1) v(fixc2)
destroy all
echo "off_r300s_d100_iii,off_r300s_d100_iii.dat,spegnimento_iii,1000,0,10,100k,1.0,1000,3.5,1e-05,evento,g10sempre_lz_iii,-,0.0,5,A_ins" >> tb_v2_casopeggiore_manifest.csv
* ---- L29d2 5: on_r300p_iii ----
alter vamp dc = 0
alter vfrq dc = 1000
alter rldm = 100k
alter rld1 = 100k
alter rld2 = 100k
alter vti dc = -100
alter vtr dc = 2.6
alter vtijk dc = -10
alter vtrjk dc = 2.6
alter vosa dc = 0
alter vosb dc = 0
alter vosf1 dc = 0
alter vosf2 dc = 0
alter ratth = 1m
alter rattb = 10k
alter rl1 = 845
alter cwire = 100p
alter vk1i dc = 1
alter vk1t dc = 1000.000000
alter vk5i dc = 1
alter vk5t dc = 1000.000000
alter vt1ri dc = 1
alter vt1rt dc = 1000.000000
alter vt1si dc = 0
alter vt1st dc = 1000.000000
alter vt2ri dc = 1
alter vt2rt dc = 1000.000000
alter vt2si dc = 0
alter vt2st dc = 1000.000000
alter vtijk dc = 1000.000000
alter vtrjk dc = 2000.000000
alter vksa dc = -10.000000
alter vksb dc = 2.601000
alter vkca dc = -9.999000
alter vkcb dc = 2.600000
alter vtiser dc = -10
alter vtrser dc = 1000
alter rbym = 1e12
alter rby1 = 1e12
alter rby2 = 1e12
alter rbcm = 220k
alter rbc1 = 470k
alter rbc2 = 470k
alter cksm = 0.1p
alter cks1 = 0.1p
alter cks2 = 0.1p
alter ccavm = 1e-18
alter ccav1 = 1e-18
alter ccav2 = 1e-18
print @cksm[capacitance] @cks1[capacitance] @cks2[capacitance] @ccavm[capacitance] @ccav1[capacitance] @ccav2[capacitance]
alter @vpp[pwl] = [ 0 0 0.15 0 0.45 15 1000 15 ]
alter @vmm[pwl] = [ 0 0 0.1 0 0.4 -15 1000 -15 ]
alter @vpwl[pwl] = [ 0 0 0.15 0 0.45 1 1000 1 ]
tran 1e-05 11.6 0 1e-05
wrdata on_r300p_iii$d v(mainjack) v(fixjack1) v(fixjack2)
wrdata on_r300p_iii_stati$d v(xls.xs) v(xlp.xs) v(dep) v(ina) v(vplus) v(vminus) v(main_a) v(mainc) v(fixc1) v(fixc2)
destroy all
echo "on_r300p_iii,on_r300p_iii.dat,accensione_iii,1000,0,10,100k,0.1,2.6,11.6,1e-05,evento,g10sempre_lz_iii,g10mai_lz_iii,0.0,5,A_ins;A_rel" >> tb_v2_casopeggiore_manifest.csv
alter vamp dc = 0
alter vfrq dc = 1000
alter rldm = 100k
alter rld1 = 100k
alter rld2 = 100k
alter vti dc = 1000
alter vtr dc = 2000
alter vtijk dc = 1.0
alter vtrjk dc = 1000
alter vosa dc = 0
alter vosb dc = 0
alter vosf1 dc = 0
alter vosf2 dc = 0
alter ratth = 1m
alter rattb = 10k
alter rl1 = 845
alter cwire = 100p
alter vk1i dc = 1
alter vk1t dc = 1000.000000
alter vk5i dc = 1
alter vk5t dc = 1000.000000
alter vt1ri dc = 1
alter vt1rt dc = 1000.000000
alter vt1si dc = 0
alter vt1st dc = 1000.000000
alter vt2ri dc = 1
alter vt2rt dc = 1000.000000
alter vt2si dc = 0
alter vt2st dc = 1000.000000
alter vtijk dc = 1000.000000
alter vtrjk dc = 2000.000000
alter vksa dc = 1.000000
alter vksb dc = 1000.001000
alter vkca dc = 1.001000
alter vkcb dc = 1000.000000
alter vtiser dc = -10
alter vtrser dc = 1000
alter rbym = 1e12
alter rby1 = 1e12
alter rby2 = 1e12
alter rbcm = 220k
alter rbc1 = 470k
alter rbc2 = 470k
alter cksm = 0.1p
alter cks1 = 0.1p
alter cks2 = 0.1p
alter ccavm = 1e-18
alter ccav1 = 1e-18
alter ccav2 = 1e-18
print @cksm[capacitance] @cks1[capacitance] @cks2[capacitance] @ccavm[capacitance] @ccav1[capacitance] @ccav2[capacitance]
alter @vpp[pwl] = [ 0 15 1.05 15 1.35 1m 1000 1m ]
alter @vmm[pwl] = [ 0 -15 1 -15 1.3 -1m 1000 -1m ]
alter @vpwl[pwl] = [ 0 1 1.05 1 1.35 0 1000 0 ]
tran 1e-05 3.5 0 1e-05
wrdata off_r300p_d0_iii$d v(mainjack) v(fixjack1) v(fixjack2)
wrdata off_r300p_d0_iii_stati$d v(xls.xs) v(xlp.xs) v(dep) v(ina) v(vplus) v(vminus) v(main_a) v(mainc) v(fixc1) v(fixc2)
destroy all
echo "off_r300p_d0_iii,off_r300p_d0_iii.dat,spegnimento_iii,1000,0,10,100k,1.0,1000,3.5,1e-05,evento,g10sempre_lz_iii,-,0.0,5,A_ins" >> tb_v2_casopeggiore_manifest.csv
alter vamp dc = 0
alter vfrq dc = 1000
alter rldm = 100k
alter rld1 = 100k
alter rld2 = 100k
alter vti dc = 1000
alter vtr dc = 2000
alter vtijk dc = 1.005
alter vtrjk dc = 1000
alter vosa dc = 0
alter vosb dc = 0
alter vosf1 dc = 0
alter vosf2 dc = 0
alter ratth = 1m
alter rattb = 10k
alter rl1 = 845
alter cwire = 100p
alter vk1i dc = 1
alter vk1t dc = 1000.000000
alter vk5i dc = 1
alter vk5t dc = 1000.000000
alter vt1ri dc = 1
alter vt1rt dc = 1000.000000
alter vt1si dc = 0
alter vt1st dc = 1000.000000
alter vt2ri dc = 1
alter vt2rt dc = 1000.000000
alter vt2si dc = 0
alter vt2st dc = 1000.000000
alter vtijk dc = 1000.000000
alter vtrjk dc = 2000.000000
alter vksa dc = 1.005000
alter vksb dc = 1000.001000
alter vkca dc = 1.006000
alter vkcb dc = 1000.000000
alter vtiser dc = -10
alter vtrser dc = 1000
alter rbym = 1e12
alter rby1 = 1e12
alter rby2 = 1e12
alter rbcm = 220k
alter rbc1 = 470k
alter rbc2 = 470k
alter cksm = 0.1p
alter cks1 = 0.1p
alter cks2 = 0.1p
alter ccavm = 1e-18
alter ccav1 = 1e-18
alter ccav2 = 1e-18
print @cksm[capacitance] @cks1[capacitance] @cks2[capacitance] @ccavm[capacitance] @ccav1[capacitance] @ccav2[capacitance]
alter @vpp[pwl] = [ 0 15 1.05 15 1.35 1m 1000 1m ]
alter @vmm[pwl] = [ 0 -15 1 -15 1.3 -1m 1000 -1m ]
alter @vpwl[pwl] = [ 0 1 1.05 1 1.35 0 1000 0 ]
tran 1e-05 3.5 0 1e-05
wrdata off_r300p_d5_iii$d v(mainjack) v(fixjack1) v(fixjack2)
wrdata off_r300p_d5_iii_stati$d v(xls.xs) v(xlp.xs) v(dep) v(ina) v(vplus) v(vminus) v(main_a) v(mainc) v(fixc1) v(fixc2)
destroy all
echo "off_r300p_d5_iii,off_r300p_d5_iii.dat,spegnimento_iii,1000,0,10,100k,1.0,1000,3.5,1e-05,evento,g10sempre_lz_iii,-,0.0,5,A_ins" >> tb_v2_casopeggiore_manifest.csv
alter vamp dc = 0
alter vfrq dc = 1000
alter rldm = 100k
alter rld1 = 100k
alter rld2 = 100k
alter vti dc = 1000
alter vtr dc = 2000
alter vtijk dc = 1.02
alter vtrjk dc = 1000
alter vosa dc = 0
alter vosb dc = 0
alter vosf1 dc = 0
alter vosf2 dc = 0
alter ratth = 1m
alter rattb = 10k
alter rl1 = 845
alter cwire = 100p
alter vk1i dc = 1
alter vk1t dc = 1000.000000
alter vk5i dc = 1
alter vk5t dc = 1000.000000
alter vt1ri dc = 1
alter vt1rt dc = 1000.000000
alter vt1si dc = 0
alter vt1st dc = 1000.000000
alter vt2ri dc = 1
alter vt2rt dc = 1000.000000
alter vt2si dc = 0
alter vt2st dc = 1000.000000
alter vtijk dc = 1000.000000
alter vtrjk dc = 2000.000000
alter vksa dc = 1.020000
alter vksb dc = 1000.001000
alter vkca dc = 1.021000
alter vkcb dc = 1000.000000
alter vtiser dc = -10
alter vtrser dc = 1000
alter rbym = 1e12
alter rby1 = 1e12
alter rby2 = 1e12
alter rbcm = 220k
alter rbc1 = 470k
alter rbc2 = 470k
alter cksm = 0.1p
alter cks1 = 0.1p
alter cks2 = 0.1p
alter ccavm = 1e-18
alter ccav1 = 1e-18
alter ccav2 = 1e-18
print @cksm[capacitance] @cks1[capacitance] @cks2[capacitance] @ccavm[capacitance] @ccav1[capacitance] @ccav2[capacitance]
alter @vpp[pwl] = [ 0 15 1.05 15 1.35 1m 1000 1m ]
alter @vmm[pwl] = [ 0 -15 1 -15 1.3 -1m 1000 -1m ]
alter @vpwl[pwl] = [ 0 1 1.05 1 1.35 0 1000 0 ]
tran 1e-05 3.5 0 1e-05
wrdata off_r300p_d20_iii$d v(mainjack) v(fixjack1) v(fixjack2)
wrdata off_r300p_d20_iii_stati$d v(xls.xs) v(xlp.xs) v(dep) v(ina) v(vplus) v(vminus) v(main_a) v(mainc) v(fixc1) v(fixc2)
destroy all
echo "off_r300p_d20_iii,off_r300p_d20_iii.dat,spegnimento_iii,1000,0,10,100k,1.0,1000,3.5,1e-05,evento,g10sempre_lz_iii,-,0.0,5,A_ins" >> tb_v2_casopeggiore_manifest.csv
alter vamp dc = 0
alter vfrq dc = 1000
alter rldm = 100k
alter rld1 = 100k
alter rld2 = 100k
alter vti dc = 1000
alter vtr dc = 2000
alter vtijk dc = 1.1
alter vtrjk dc = 1000
alter vosa dc = 0
alter vosb dc = 0
alter vosf1 dc = 0
alter vosf2 dc = 0
alter ratth = 1m
alter rattb = 10k
alter rl1 = 845
alter cwire = 100p
alter vk1i dc = 1
alter vk1t dc = 1000.000000
alter vk5i dc = 1
alter vk5t dc = 1000.000000
alter vt1ri dc = 1
alter vt1rt dc = 1000.000000
alter vt1si dc = 0
alter vt1st dc = 1000.000000
alter vt2ri dc = 1
alter vt2rt dc = 1000.000000
alter vt2si dc = 0
alter vt2st dc = 1000.000000
alter vtijk dc = 1000.000000
alter vtrjk dc = 2000.000000
alter vksa dc = 1.100000
alter vksb dc = 1000.001000
alter vkca dc = 1.101000
alter vkcb dc = 1000.000000
alter vtiser dc = -10
alter vtrser dc = 1000
alter rbym = 1e12
alter rby1 = 1e12
alter rby2 = 1e12
alter rbcm = 220k
alter rbc1 = 470k
alter rbc2 = 470k
alter cksm = 0.1p
alter cks1 = 0.1p
alter cks2 = 0.1p
alter ccavm = 1e-18
alter ccav1 = 1e-18
alter ccav2 = 1e-18
print @cksm[capacitance] @cks1[capacitance] @cks2[capacitance] @ccavm[capacitance] @ccav1[capacitance] @ccav2[capacitance]
alter @vpp[pwl] = [ 0 15 1.05 15 1.35 1m 1000 1m ]
alter @vmm[pwl] = [ 0 -15 1 -15 1.3 -1m 1000 -1m ]
alter @vpwl[pwl] = [ 0 1 1.05 1 1.35 0 1000 0 ]
tran 1e-05 3.5 0 1e-05
wrdata off_r300p_d100_iii$d v(mainjack) v(fixjack1) v(fixjack2)
wrdata off_r300p_d100_iii_stati$d v(xls.xs) v(xlp.xs) v(dep) v(ina) v(vplus) v(vminus) v(main_a) v(mainc) v(fixc1) v(fixc2)
destroy all
echo "off_r300p_d100_iii,off_r300p_d100_iii.dat,spegnimento_iii,1000,0,10,100k,1.0,1000,3.5,1e-05,evento,g10sempre_lz_iii,-,0.0,5,A_ins" >> tb_v2_casopeggiore_manifest.csv
* ---- L29d2 5: on_r300m_iii ----
alter vamp dc = 0
alter vfrq dc = 1000
alter rldm = 100k
alter rld1 = 100k
alter rld2 = 100k
alter vti dc = -100
alter vtr dc = 2.6
alter vtijk dc = -10
alter vtrjk dc = 2.6
alter vosa dc = 0
alter vosb dc = 0
alter vosf1 dc = 0
alter vosf2 dc = 0
alter ratth = 1m
alter rattb = 10k
alter rl1 = 845
alter cwire = 100p
alter vk1i dc = 1
alter vk1t dc = 1000.000000
alter vk5i dc = 1
alter vk5t dc = 1000.000000
alter vt1ri dc = 1
alter vt1rt dc = 1000.000000
alter vt1si dc = 0
alter vt1st dc = 1000.000000
alter vt2ri dc = 1
alter vt2rt dc = 1000.000000
alter vt2si dc = 0
alter vt2st dc = 1000.000000
alter vtijk dc = 1000.000000
alter vtrjk dc = 2000.000000
alter vksa dc = -10.000000
alter vksb dc = 2.601000
alter vkca dc = -9.999000
alter vkcb dc = 2.600000
alter vtiser dc = -10
alter vtrser dc = 1000
alter rbym = 1e12
alter rby1 = 1e12
alter rby2 = 1e12
alter rbcm = 220k
alter rbc1 = 470k
alter rbc2 = 470k
alter cksm = 0.1p
alter cks1 = 0.1p
alter cks2 = 0.1p
alter ccavm = 1e-18
alter ccav1 = 1e-18
alter ccav2 = 1e-18
print @cksm[capacitance] @cks1[capacitance] @cks2[capacitance] @ccavm[capacitance] @ccav1[capacitance] @ccav2[capacitance]
alter @vpp[pwl] = [ 0 0 0.1 0 0.4 15 1000 15 ]
alter @vmm[pwl] = [ 0 0 0.15 0 0.45 -15 1000 -15 ]
alter @vpwl[pwl] = [ 0 0 0.1 0 0.4 1 1000 1 ]
tran 1e-05 11.6 0 1e-05
wrdata on_r300m_iii$d v(mainjack) v(fixjack1) v(fixjack2)
wrdata on_r300m_iii_stati$d v(xls.xs) v(xlp.xs) v(dep) v(ina) v(vplus) v(vminus) v(main_a) v(mainc) v(fixc1) v(fixc2)
destroy all
echo "on_r300m_iii,on_r300m_iii.dat,accensione_iii,1000,0,10,100k,0.1,2.6,11.6,1e-05,evento,g10sempre_lz_iii,g10mai_lz_iii,0.0,5,A_ins;A_rel" >> tb_v2_casopeggiore_manifest.csv
alter vamp dc = 0
alter vfrq dc = 1000
alter rldm = 100k
alter rld1 = 100k
alter rld2 = 100k
alter vti dc = 1000
alter vtr dc = 2000
alter vtijk dc = 1.0
alter vtrjk dc = 1000
alter vosa dc = 0
alter vosb dc = 0
alter vosf1 dc = 0
alter vosf2 dc = 0
alter ratth = 1m
alter rattb = 10k
alter rl1 = 845
alter cwire = 100p
alter vk1i dc = 1
alter vk1t dc = 1000.000000
alter vk5i dc = 1
alter vk5t dc = 1000.000000
alter vt1ri dc = 1
alter vt1rt dc = 1000.000000
alter vt1si dc = 0
alter vt1st dc = 1000.000000
alter vt2ri dc = 1
alter vt2rt dc = 1000.000000
alter vt2si dc = 0
alter vt2st dc = 1000.000000
alter vtijk dc = 1000.000000
alter vtrjk dc = 2000.000000
alter vksa dc = 1.000000
alter vksb dc = 1000.001000
alter vkca dc = 1.001000
alter vkcb dc = 1000.000000
alter vtiser dc = -10
alter vtrser dc = 1000
alter rbym = 1e12
alter rby1 = 1e12
alter rby2 = 1e12
alter rbcm = 220k
alter rbc1 = 470k
alter rbc2 = 470k
alter cksm = 0.1p
alter cks1 = 0.1p
alter cks2 = 0.1p
alter ccavm = 1e-18
alter ccav1 = 1e-18
alter ccav2 = 1e-18
print @cksm[capacitance] @cks1[capacitance] @cks2[capacitance] @ccavm[capacitance] @ccav1[capacitance] @ccav2[capacitance]
alter @vpp[pwl] = [ 0 15 1 15 1.3 1m 1000 1m ]
alter @vmm[pwl] = [ 0 -15 1.05 -15 1.35 -1m 1000 -1m ]
alter @vpwl[pwl] = [ 0 1 1 1 1.3 0 1000 0 ]
tran 1e-05 3.5 0 1e-05
wrdata off_r300m_d0_iii$d v(mainjack) v(fixjack1) v(fixjack2)
wrdata off_r300m_d0_iii_stati$d v(xls.xs) v(xlp.xs) v(dep) v(ina) v(vplus) v(vminus) v(main_a) v(mainc) v(fixc1) v(fixc2)
destroy all
echo "off_r300m_d0_iii,off_r300m_d0_iii.dat,spegnimento_iii,1000,0,10,100k,1.0,1000,3.5,1e-05,evento,g10sempre_lz_iii,-,0.0,5,A_ins" >> tb_v2_casopeggiore_manifest.csv
alter vamp dc = 0
alter vfrq dc = 1000
alter rldm = 100k
alter rld1 = 100k
alter rld2 = 100k
alter vti dc = 1000
alter vtr dc = 2000
alter vtijk dc = 1.005
alter vtrjk dc = 1000
alter vosa dc = 0
alter vosb dc = 0
alter vosf1 dc = 0
alter vosf2 dc = 0
alter ratth = 1m
alter rattb = 10k
alter rl1 = 845
alter cwire = 100p
alter vk1i dc = 1
alter vk1t dc = 1000.000000
alter vk5i dc = 1
alter vk5t dc = 1000.000000
alter vt1ri dc = 1
alter vt1rt dc = 1000.000000
alter vt1si dc = 0
alter vt1st dc = 1000.000000
alter vt2ri dc = 1
alter vt2rt dc = 1000.000000
alter vt2si dc = 0
alter vt2st dc = 1000.000000
alter vtijk dc = 1000.000000
alter vtrjk dc = 2000.000000
alter vksa dc = 1.005000
alter vksb dc = 1000.001000
alter vkca dc = 1.006000
alter vkcb dc = 1000.000000
alter vtiser dc = -10
alter vtrser dc = 1000
alter rbym = 1e12
alter rby1 = 1e12
alter rby2 = 1e12
alter rbcm = 220k
alter rbc1 = 470k
alter rbc2 = 470k
alter cksm = 0.1p
alter cks1 = 0.1p
alter cks2 = 0.1p
alter ccavm = 1e-18
alter ccav1 = 1e-18
alter ccav2 = 1e-18
print @cksm[capacitance] @cks1[capacitance] @cks2[capacitance] @ccavm[capacitance] @ccav1[capacitance] @ccav2[capacitance]
alter @vpp[pwl] = [ 0 15 1 15 1.3 1m 1000 1m ]
alter @vmm[pwl] = [ 0 -15 1.05 -15 1.35 -1m 1000 -1m ]
alter @vpwl[pwl] = [ 0 1 1 1 1.3 0 1000 0 ]
tran 1e-05 3.5 0 1e-05
wrdata off_r300m_d5_iii$d v(mainjack) v(fixjack1) v(fixjack2)
wrdata off_r300m_d5_iii_stati$d v(xls.xs) v(xlp.xs) v(dep) v(ina) v(vplus) v(vminus) v(main_a) v(mainc) v(fixc1) v(fixc2)
destroy all
echo "off_r300m_d5_iii,off_r300m_d5_iii.dat,spegnimento_iii,1000,0,10,100k,1.0,1000,3.5,1e-05,evento,g10sempre_lz_iii,-,0.0,5,A_ins" >> tb_v2_casopeggiore_manifest.csv
alter vamp dc = 0
alter vfrq dc = 1000
alter rldm = 100k
alter rld1 = 100k
alter rld2 = 100k
alter vti dc = 1000
alter vtr dc = 2000
alter vtijk dc = 1.02
alter vtrjk dc = 1000
alter vosa dc = 0
alter vosb dc = 0
alter vosf1 dc = 0
alter vosf2 dc = 0
alter ratth = 1m
alter rattb = 10k
alter rl1 = 845
alter cwire = 100p
alter vk1i dc = 1
alter vk1t dc = 1000.000000
alter vk5i dc = 1
alter vk5t dc = 1000.000000
alter vt1ri dc = 1
alter vt1rt dc = 1000.000000
alter vt1si dc = 0
alter vt1st dc = 1000.000000
alter vt2ri dc = 1
alter vt2rt dc = 1000.000000
alter vt2si dc = 0
alter vt2st dc = 1000.000000
alter vtijk dc = 1000.000000
alter vtrjk dc = 2000.000000
alter vksa dc = 1.020000
alter vksb dc = 1000.001000
alter vkca dc = 1.021000
alter vkcb dc = 1000.000000
alter vtiser dc = -10
alter vtrser dc = 1000
alter rbym = 1e12
alter rby1 = 1e12
alter rby2 = 1e12
alter rbcm = 220k
alter rbc1 = 470k
alter rbc2 = 470k
alter cksm = 0.1p
alter cks1 = 0.1p
alter cks2 = 0.1p
alter ccavm = 1e-18
alter ccav1 = 1e-18
alter ccav2 = 1e-18
print @cksm[capacitance] @cks1[capacitance] @cks2[capacitance] @ccavm[capacitance] @ccav1[capacitance] @ccav2[capacitance]
alter @vpp[pwl] = [ 0 15 1 15 1.3 1m 1000 1m ]
alter @vmm[pwl] = [ 0 -15 1.05 -15 1.35 -1m 1000 -1m ]
alter @vpwl[pwl] = [ 0 1 1 1 1.3 0 1000 0 ]
tran 1e-05 3.5 0 1e-05
wrdata off_r300m_d20_iii$d v(mainjack) v(fixjack1) v(fixjack2)
wrdata off_r300m_d20_iii_stati$d v(xls.xs) v(xlp.xs) v(dep) v(ina) v(vplus) v(vminus) v(main_a) v(mainc) v(fixc1) v(fixc2)
destroy all
echo "off_r300m_d20_iii,off_r300m_d20_iii.dat,spegnimento_iii,1000,0,10,100k,1.0,1000,3.5,1e-05,evento,g10sempre_lz_iii,-,0.0,5,A_ins" >> tb_v2_casopeggiore_manifest.csv
alter vamp dc = 0
alter vfrq dc = 1000
alter rldm = 100k
alter rld1 = 100k
alter rld2 = 100k
alter vti dc = 1000
alter vtr dc = 2000
alter vtijk dc = 1.1
alter vtrjk dc = 1000
alter vosa dc = 0
alter vosb dc = 0
alter vosf1 dc = 0
alter vosf2 dc = 0
alter ratth = 1m
alter rattb = 10k
alter rl1 = 845
alter cwire = 100p
alter vk1i dc = 1
alter vk1t dc = 1000.000000
alter vk5i dc = 1
alter vk5t dc = 1000.000000
alter vt1ri dc = 1
alter vt1rt dc = 1000.000000
alter vt1si dc = 0
alter vt1st dc = 1000.000000
alter vt2ri dc = 1
alter vt2rt dc = 1000.000000
alter vt2si dc = 0
alter vt2st dc = 1000.000000
alter vtijk dc = 1000.000000
alter vtrjk dc = 2000.000000
alter vksa dc = 1.100000
alter vksb dc = 1000.001000
alter vkca dc = 1.101000
alter vkcb dc = 1000.000000
alter vtiser dc = -10
alter vtrser dc = 1000
alter rbym = 1e12
alter rby1 = 1e12
alter rby2 = 1e12
alter rbcm = 220k
alter rbc1 = 470k
alter rbc2 = 470k
alter cksm = 0.1p
alter cks1 = 0.1p
alter cks2 = 0.1p
alter ccavm = 1e-18
alter ccav1 = 1e-18
alter ccav2 = 1e-18
print @cksm[capacitance] @cks1[capacitance] @cks2[capacitance] @ccavm[capacitance] @ccav1[capacitance] @ccav2[capacitance]
alter @vpp[pwl] = [ 0 15 1 15 1.3 1m 1000 1m ]
alter @vmm[pwl] = [ 0 -15 1.05 -15 1.35 -1m 1000 -1m ]
alter @vpwl[pwl] = [ 0 1 1 1 1.3 0 1000 0 ]
tran 1e-05 3.5 0 1e-05
wrdata off_r300m_d100_iii$d v(mainjack) v(fixjack1) v(fixjack2)
wrdata off_r300m_d100_iii_stati$d v(xls.xs) v(xlp.xs) v(dep) v(ina) v(vplus) v(vminus) v(main_a) v(mainc) v(fixc1) v(fixc2)
destroy all
echo "off_r300m_d100_iii,off_r300m_d100_iii.dat,spegnimento_iii,1000,0,10,100k,1.0,1000,3.5,1e-05,evento,g10sempre_lz_iii,-,0.0,5,A_ins" >> tb_v2_casopeggiore_manifest.csv
.endc

.end
