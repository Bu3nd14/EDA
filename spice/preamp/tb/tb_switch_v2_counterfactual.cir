tb_switch_v2_counterfactual.cir - what the REJECTED arrangement would do
* ADR-004 rejected putting the relay contact in series with R_f (the loop
* leg). This deck shows why, on the same circuit, by opening R138 (R_f)
* to 1 Gohm - which is what an open contact in that position IS.
*
* Prediction: with R_f open there is no feedback path at all, the input pair
* sees only its own offset amplified by the full open-loop gain, and the
* output sits hard against a rail. Compare with tb_switch_v2.cir, where the
* same relay in the ADR-004 position never moves the output outside the
* band bounded by the two gain settings.
*
* This is the falsifiable half of the V2 claim: it is not enough to show the
* chosen arrangement behaves; the rejected one has to be shown to misbehave,
* or the design decision carries no information.

.include @REPO@/spice/preamp/placeholder_devices.lib
.include @REPO@/spice/preamp/gain_block_flat.inc

VPP VPLUS 0 DC 15
VMM VMINUS 0 DC -15
VSRC SRCN 0 DC 0 AC 1
RSRC SRCN IN 430

CSTRAY RG 0 15p
RRG    RG 0 1G

RISO   OUT OUTA 47
COUT   OUTA JACK 4.7u
RBLEED JACK 0 220k
RLOAD  JACK 0 100k

.control
* In the REJECTED topology the relay sits in the R_f leg, so R_g is
* permanently strapped to ground: RRG = 0.1 ohm in both states below.
alter rrg = 0.1
echo "--- A: contact CLOSED (R_f = 1.50k), R_g strapped: the +10 dB state ---"
op
print v(OUT) v(FB) v(NX) v(NY)
echo "--- B: contact OPEN (R_f = 1e12), R_g still strapped: loop is BROKEN ---"
alter r138 = 1e12
op
print v(OUT) v(FB) v(NX) v(NY)
echo "--- C: closed again, to prove B was not a solver artefact ---"
alter r138 = 1.50k
op
print v(OUT) v(FB)
.endc

.end
