tb_noise_breakdown.cir - which devices actually make the noise (E5)
* Single-frequency noise summary at 1 kHz so ngspice prints the per-device
* contribution table, plus the integrated 20 Hz - 20 kHz totals for the five
* configurations that matter (L27 added E, the +3 dB mode of ADR-026).
* REMINDER: since L39 the models are the manufacturer's, and only the
* LSK489A carries KF. 1/f noise is on the input pair and nowhere else: for
* every other device these are thermal + shot noise only, i.e. a FLOOR.

.include @REPO@/models/jfet/lsk489.lib
.include @REPO@/models/bjt_npn/mmbt5551.lib
.include @REPO@/models/bjt_pnp/mmbt5401.lib
.include @REPO@/models/bjt_npn/mje15032.lib
.include @REPO@/models/bjt_pnp/mje15033.lib
.include @REPO@/models/diodes/1n4148.lib
* L39 (NC-017): every active device in this deck is a vendor model from
* models/, each next to its .provenance.json:
*   LSK489   - vendor model LSK489A, the published corner sample (I_DSS
*              2.59 mA, below the group-B window of ADR-031)
*   LS352    - vendor model LS350 (ADR-018), included on the next line
*   MMBT5551 - vendor model, Diodes Inc. (ADR-017)
*   MMBT5401 - vendor model, Diodes Inc. (ADR-017)
*   MJE15032 - vendor model Qmje15032, onsemi (NC-024, NC-025)
*   MJE15033 - vendor model Qmje15033, onsemi (NC-025)
*   1N4148   - vendor model D1N914, onsemi (docs/limitations.md #20)
* Only the LSK489A carries KF: 1/f noise is on the input pair and nowhere
* else. No model carries part-to-part spread.
.include @REPO@/models/bjt_pnp/ls350.lib
.include @REPO@/spice/preamp/gain_block_flat.inc

VPP VPLUS 0 DC 15
VMM VMINUS 0 DC -15
VSRC SRCN 0 DC 0 AC 1
RSRC SRCN IN 430

* Gain-relay contacts (L27, ADR-026): open = 15 pF + 1 G, closed = 0.1 ohm.
CSTRAY   RG   0 15p
RRG      RG   0 1G
CSTRAY10 RG10 0 15p
RRG10    RG10 0 1G

RISO   OUT OUTA 47
COUT   OUTA JACK 4.7u
RBLEED JACK 0 220k
RLOAD  JACK 0 100k

.control
echo "===== per-device noise contributions at 1 kHz, 0 dB mode, Rsrc=430 ====="
noise v(JACK) VSRC lin 2 1000 1001 1
destroy all

* --- wrdata (L5): uno spettro PER CONFIGURAZIONE ----------------------
* NOMI PARAMETRIZZATI: un `$var` dentro un nome di file non si chiude da
* solo - ngspice fa entrare nel nome della variabile anche `.`, `-` e `_`,
* quindi `wrdata x_$lbl.txt` cercherebbe la variabile "lbl.txt". Un `$`
* invece TERMINA il nome: la forma che funziona e' `$lbl$t` con t = ".txt".
* Misurato con una sonda in L5, non dedotto.
*
* DOVE: plot `noise1`. Un'analisi `noise` ne produce DUE - noise1 (densita'
* spettrale, 301 righe) e noise2 (integrato, 1 riga) - e il `setplot`
* decide quale si scrive. Il `wrdata` sta DENTRO il ciclo e PRIMA del
* `destroy all`: senza quel destroy la seconda `noise` creerebbe
* noise3/noise4 e il `setplot noise2` continuerebbe a leggere la PRIMA
* configurazione. E' docs/limitations.md #10, ed e' esattamente il difetto
* che L5 corregge in tb_zout_psrr_noise.cir - qui il ciclo lo evita gia'.
*
* COSA NON SI SCRIVE, di proposito:
*  - la sezione per dispositivo a 1 kHz qui sopra: e' gia' il lavoro di
*    tb_noise_vectors.cir (L4). Due file per lo stesso dato divergono.
*  - gli integrati onoise_total/inoise_total: sono scalari, restano
*    stampati nel log. Da L39 vengono dai modelli del costruttore.
*
* COLONNE (301 righe, 20 Hz - 20 kHz, 100 punti/decade). Per ogni vettore
* una COPPIA (frequenza, valore): le colonne PARI sono la frequenza
* ripetuta, i dati sono le DISPARI.
*   col0 = frequenza [Hz]   col1 = onoise_spectrum [V/sqrt(Hz)]
*   col2 = frequenza [Hz]   col3 = inoise_spectrum [V/sqrt(Hz)]
* La configurazione non e' una colonna: e' nel NOME del file.
*
* NOTA: nessun file si chiama tb_noise_breakdown_wrdata.txt, quindi il
* percorso primario di run_simulation.sh avvisa e scrive un
* tb_noise_breakdown.json con rows: 0. E' atteso: i 5 file veri li
* converte il SECONDO passaggio, che guarda i file prodotti.
*
* ATTENZIONE DI MERITO: da L39 i modelli sono del costruttore, ma solo
* l'LSK489A porta KF. Fuori dalla coppia d'ingresso qui NON c'e' rumore 1/f:
* e' un pavimento termico+shot, non una previsione (NC-004).
* ---------------------------------------------------------------------
set t = .txt
echo "===== integrated totals, 20 Hz - 20 kHz ====="
foreach cfg 1 2 3 4 5
  if $cfg = 1
    alter rrg = 1G
    alter rrg10 = 1G
    alter rsrc = 1
    set lbl = "a_0db_1r"
    echo "A) 0 dB, source 1 ohm      (block A intrinsic)"
  end
  if $cfg = 2
    alter rrg = 1G
    alter rrg10 = 1G
    alter rsrc = 430
    set lbl = "b_0db_430r"
    echo "B) 0 dB, source 430 ohm    (block A on the tube phono)"
  end
  if $cfg = 3
    alter rrg = 1G
    alter rrg10 = 1G
    alter rsrc = 2500
    set lbl = "c_0db_2500r"
    echo "C) 0 dB, source 2500 ohm   (block B, attenuator mid-rotation)"
  end
  if $cfg = 4
    alter rrg = 0.1
    alter rrg10 = 0.1
    alter rsrc = 2500
    set lbl = "d_10db_2500r"
    echo "D) +10 dB, source 2500 ohm (block B worst case)"
  end
  if $cfg = 5
    alter rrg = 0.1
    alter rrg10 = 1G
    alter rsrc = 2500
    set lbl = "e_3db_2500r"
    echo "E) +3 dB, source 2500 ohm  (block B, K1 closed, K5 open)"
  end
  noise v(JACK) VSRC dec 100 20 20000 1
  setplot noise1
  wrdata tb_noise_breakdown_$lbl$t onoise_spectrum inoise_spectrum
  setplot noise2
  print onoise_total inoise_total
  destroy all
end
.endc

.end
