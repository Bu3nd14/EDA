tb_ac.cir - closed-loop response over the V1 source/load/mode matrix
* The point of this deck is ONE falsifiable claim, from ADR-014:
*   "the HF response must not move when the volume knob moves."
* The stepped attenuator's output impedance runs 0 -> 2500 -> 0 ohm across
* the rotation (R/4 at mid-rotation on a 10 kohm ladder). If the cascode is
* doing its job, the 20 kHz response must be the same for RSRC = 0 and
* RSRC = 2500. If it is not, ADR-014 was not implemented, whatever the
* schematic says.
* Also covers: phono cathode follower (430 ohm), K11 (1.5 ohm), and the
* low-frequency corner set by the 4.7 uF output cap (E8/ADR-007).

.include @REPO@/spice/preamp/placeholder_devices.lib
.include @REPO@/spice/preamp/gain_block_flat.inc

VPP VPLUS 0 DC 15
VMM VMINUS 0 DC -15
VSRC SRCN 0 DC 0 AC 1
RSRC SRCN IN 1.5

CSTRAY RG 0 15p
RRG    RG 0 1G

RISO   OUT OUTA 47
COUT   OUTA JACK 4.7u
RBLEED JACK 0 220k
RLOAD  JACK 0 100k
CCABLE JACK 0 100p

.control
set units = degrees
foreach mode 1G 0.1
  alter rrg = $mode
  foreach rs 1.5 430 2500 10k
    alter rsrc = $rs
    ac dec 200 0.2 30meg
    let G = db(v(JACK))
    meas ac g1k   find G at=1000
    meas ac g20   find G at=20
    meas ac g20k  find G at=20000
    meas ac g100k find G at=100000
    let Gn = G - g1k
    meas ac fhi when Gn=-3 rise=1
    meas ac flo when Gn=-3 fall=1
    echo "RRG=$mode  RSRC=$rs"
    print g1k g20 g20k g100k fhi flo
    destroy all
  end
end
* low-frequency corner with the 50 kohm Stax-like load instead of 100k
alter rrg = 1G
alter rsrc = 430
alter rload = 50k
ac dec 200 0.1 1000
let G = db(v(JACK))
meas ac g1kb find G at=1000
meas ac g20b find G at=20
meas ac g5b  find G at=5
echo "LF corner, RLOAD=50k, RBLEED=220k, COUT=4.7u"
print g1kb g20b g5b
.endc

.end
