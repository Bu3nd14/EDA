tb_loop_blockA.cir - loop gain of BLOCK A, loaded as preamp_audio.py wires it since L17 (ADR-023)
* Prima riga = titolo (docs/limitations.md #10).
*
* WHAT CHANGED IN L17. Until L17 block A drove the attenuator AND the two
* fixed outputs straight from its feedback node (ADR-008). This deck still
* carried the values ADR-008 was first written with - 100 ohm, 2.2 uF, 50 k -
* which the addenda had superseded (NC-002). Since ADR-023 each fixed output
* has its own buffer, so block A's output node carries:
*   - the 10 k stepped attenuator (manopola al massimo: il carico piu' pesante);
*   - the INPUTS of two buffers (a JFET gate behind 100 ohm, pF);
*   - the harness wiring to the front-panel attenuator: CWIRE, swept.
* The buffers are instantiated from gain_block.subckt with their own fixed
* loads, so what block A sees is the real input of a real block, not a guess.
*
* TWO LOADS, selected by resistors (1 mohm / 1e12), same deck:
*   load 1  NUOVO   - ADR-023, as above.
*   load 2  CANONICO ADR-008 - the load NC-002 measured by hand: 47 ohm +
*           4.7 uF + 470 k on each fixed output, straight on OUT, 50 k at each
*           jack. It is here as the CONTROL: it must reproduce NC-002's
*           41.98 deg at 4.7 nF. If it does not, this deck measures something
*           else and its load-1 numbers mean nothing.
*
* CWIRE: 1 fF to 4.7 nF straight on the output node. 4.7 nF is V1's margin
* probe (ADR-019: 60 deg everywhere, capacitive worst case included), far more
* than a 20 cm harness can present.
*
* LOOP BREAK: as in tb_loop.cir. R109 (the FB-side gate stopper) is opened
* and replaced by RBRK + VINJ in series; T = v(fb)/v(g2).
*
* NOT A REMEDY. NC-002 is L12's. This deck only measures where L12 starts.
* Gain relay not fitted (ADR-006): unity gain, RG left on 1 G.
* PROVISIONAL - placeholder device models, see tb_loop.cir header.

.include @REPO@/spice/preamp/placeholder_devices.lib
* L22: the input current mirror is no longer a placeholder. It is an
* LS352 (ADR-018) and this is its VENDOR model - the only real device
* model in this deck besides the LSK489. Every OTHER device here is
* still a hand-written placeholder.
.include @REPO@/models/bjt_pnp/ls350.lib
* the block under test, flat (its devices are top-level: R109 can be altered)
.include @REPO@/spice/preamp/gain_block_flat.inc
* the two buffers it drives, as subcircuits
.include @REPO@/spice/preamp/gain_block.subckt

VPP VPLUS 0 DC 15
VMM VMINUS 0 DC -15
VIN IN 0 DC 0

* R_g / relay not fitted on block A
RRG RG 0 1G

RBRK FB NBRK 100
VINJ NBRK G2 DC 0 AC 1

* --- harness capacitance and attenuator, both loads ---
CWIRE  OUT 0 1f
RATT   OUT 0 10k

* --- load 1: the two buffers of ADR-023, each with its fixed output ---
RSELN1 OUT BIN1 1m
RSELN2 OUT BIN2 1m
XF1 BIN1 OUTF1 FBF1 RGF1 VPLUS VMINUS GAINBLOCK
RRGF1 RGF1 0 1G
XF2 BIN2 OUTF2 FBF2 RGF2 VPLUS VMINUS GAINBLOCK
RRGF2 RGF2 0 1G
RSEP1 OUTF1 FIX1 47
CFIX1 FIX1 J1 4.7u
RBL1  J1 0 470k
RJ1   J1 0 10k
RSEP2 OUTF2 FIX2 47
CFIX2 FIX2 J2 4.7u
RBL2  J2 0 470k
RJ2   J2 0 50k

* --- load 2: the canonical ADR-008 load NC-002 measured (control) ---
RSELV1 OUT VFIX1A 1e12
RSELV2 OUT VFIX2A 1e12
RVSEP1 VFIX1A VFIX1 47
CVFIX1 VFIX1 VJ1 4.7u
RVBL1  VJ1 0 470k
RVJ1   VJ1 0 50k
RVSEP2 VFIX2A VFIX2 47
CVFIX2 VFIX2 VJ2 4.7u
RVBL2  VJ2 0 470k
RVJ2   VJ2 0 50k

.control
* --- wrdata (L5): una curva di anello PER ITERAZIONE ------------------
* NOMI PARAMETRIZZATI: un `$var` in un nome di file non si chiude da solo -
* ngspice fa entrare nel nome della variabile anche `.`, `-` e `_`. Un `$`
* invece TERMINA il nome: la forma che funziona e' `$cw$t` con t = ".txt".
* Misurato con una sonda in L5, non dedotto.
*
* Solo il carico 1 scrive le curve (tb_loop_blockA_<cw>.txt); il controllo
* stampa margine e attraversamento nel log e in tb_loop_blockA.csv.
*
* COLONNE delle curve (~801 righe, 1 Hz - 100 MHz, 100 punti/decade).
*   col0 = frequenza [Hz]   col1 = Tdb = |T| in dB
*   col2 = frequenza [Hz]   col3 = Tph = fase di T in GRADI
* Margine di fase = |Tph| dove Tdb attraversa lo zero (vedi tb_loop.cir).
*
* DOVE: dentro il ciclo, PRIMA del `destroy all` - senza quel destroy le
* `ac` successive creerebbero ac2, ac3, ... e un `wrdata` fuori dal ciclo
* leggerebbe il plot sbagliato in silenzio (docs/limitations.md #10).
* ---------------------------------------------------------------------
set t = .txt
alter r109 = 1G
set units = degrees
echo "carico,cwire,fcross_hz,pm_deg,tdb_10hz" > tb_loop_blockA.csv
foreach ld 1 2
  if $ld = 1
    alter rseln1 = 1m
    alter rseln2 = 1m
    alter rselv1 = 1e12
    alter rselv2 = 1e12
  else
    alter rseln1 = 1e12
    alter rseln2 = 1e12
    alter rselv1 = 1m
    alter rselv2 = 1m
  end
  foreach cw 1f 47p 100p 220p 470p 1n 2.2n 4.7n
    alter cwire = $cw
    ac dec 100 1 100meg
    let T = v(fb)/v(g2)
    let Tdb = db(T)
    let Tph = ph(T)
    meas ac fcross when Tdb=0
    meas ac pmarg find Tph when Tdb=0
    meas ac tdc find Tdb at=10
    echo "BLOCK A  carico=$ld  Cwire=$cw"
    print fcross pmarg tdc
    echo "$ld,$cw,$&fcross,$&pmarg,$&tdc" >> tb_loop_blockA.csv
    if $ld = 1
      wrdata tb_loop_blockA_$cw$t Tdb Tph
    end
    destroy all
  end
end
.endc

.end
