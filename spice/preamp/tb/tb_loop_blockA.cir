tb_loop_blockA.cir - loop gain of BLOCK A, loaded exactly as ADR-008 wires it
* BLOCK A has NO output isolation resistor: its feedback take-off IS the node
* that drives the 10 kohm stepped attenuator, plus the two 100 ohm isolation
* resistors feeding the fixed outputs. So the wiring capacitance to the
* front-panel attenuator sits DIRECTLY on the loop's output node, with no
* 47 ohm buffer in front of it - the opposite of BLOCK B's situation.
* CWIRE is swept from 0 to 1 nF: 1 nF is far more than a 20 cm harness can
* present, and is here as a margin probe, not as a realistic value.
* Gain relay not fitted (ADR-006): unity gain, RG left open.
* PROVISIONAL - placeholder device models, see tb_loop.cir header.

.include @REPO@/spice/preamp/placeholder_devices.lib
.include @REPO@/spice/preamp/gain_block_flat.inc

VPP VPLUS 0 DC 15
VMM VMINUS 0 DC -15
VIN IN 0 DC 0

* R_g / relay not fitted on block A
RRG RG 0 1G

RBRK FB NBRK 100
VINJ NBRK G2 DC 0 AC 1

* --- ADR-008 load: attenuator + two isolated fixed outputs ---
CWIRE  OUT 0 1f
RATT   OUT 0 10k
RSEP1  OUT FIX1 100
CFIX1  FIX1 J1 2.2u
RJ1    J1 0 50k
RSEP2  OUT FIX2 100
CFIX2  FIX2 J2 2.2u
RJ2    J2 0 50k

.control
* --- wrdata (L5): una curva di anello PER ITERAZIONE, 6 file ----------
* NOMI PARAMETRIZZATI: un `$var` in un nome di file non si chiude da solo
* - ngspice fa entrare nel nome della variabile anche `.`, `-` e `_`,
* quindi `wrdata tb_loop_blockA_$cw.txt` cercherebbe la variabile
* "cw.txt". Un `$` invece TERMINA il nome: la forma che funziona e'
* `$cw$t` con t = ".txt". Misurato con una sonda in L5, non dedotto.
*
* Qui il ciclo e' uno solo (BLOCK A non ha il relais di guadagno,
* ADR-006), quindi non serve l'etichetta di modalita': il nome porta
* direttamente la capacita' di cablaggio.
*   tb_loop_blockA_{1f,47p,100p,220p,470p,1n}.txt
*
* DOVE: dentro il ciclo, PRIMA del `destroy all` - senza quel destroy le
* `ac` successive creerebbero ac2, ac3, ... e un `wrdata` fuori dal ciclo
* leggerebbe il plot sbagliato in silenzio (docs/limitations.md #10).
*
* Nessun file si chiama tb_loop_blockA_wrdata.txt, quindi run_simulation.sh
* avvisa e scrive un tb_loop_blockA.json con rows: 0; i 6 file veri li
* converte il SECONDO passaggio. E' atteso, non un guasto.
*
* COLONNE (~801 righe, 1 Hz - 100 MHz, 100 punti/decade). Coppie
* (frequenza, valore): le PARI sono la frequenza ripetuta, i dati le
* DISPARI.
*   col0 = frequenza [Hz]   col1 = Tdb = |T| in dB
*   col2 = frequenza [Hz]   col3 = Tph = fase di T in GRADI
* Margine di fase = |Tph| dove Tdb attraversa lo zero (vedi tb_loop.cir).
*
* PROVVISORIO: modelli segnaposto, capacita' scelte a mano. Da rifare sui
* modelli vendor (L6-L7).
* ---------------------------------------------------------------------
set t = .txt
alter r109 = 1G
set units = degrees
foreach cw 1f 47p 100p 220p 470p 1n
  alter cwire = $cw
  ac dec 100 1 100meg
  let T = v(fb)/v(g2)
  let Tdb = db(T)
  let Tph = ph(T)
  meas ac fcross when Tdb=0
  meas ac pmarg find Tph when Tdb=0
  meas ac tdc find Tdb at=10
  echo "BLOCK A  Cwire=$cw"
  print fcross pmarg tdc
  wrdata tb_loop_blockA_$cw$t Tdb Tph
  destroy all
end
.endc

.end
