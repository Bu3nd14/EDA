tb_noise_vectors.cir - list the per-device noise vectors ngspice keeps
.include @REPO@/spice/preamp/placeholder_devices.lib
* L22: the input current mirror is no longer a placeholder. It is an
* LS352 (ADR-018) and this is its VENDOR model - the only real device
* model in this deck besides the LSK489. Every OTHER device here is
* still a hand-written placeholder.
.include @REPO@/models/bjt_pnp/ls350.lib
.include @REPO@/spice/preamp/gain_block_flat.inc
VPP VPLUS 0 DC 15
VMM VMINUS 0 DC -15
VSRC SRCN 0 DC 0 AC 1
RSRC SRCN IN 430
CSTRAY RG 0 15p
CSTRAY10 RG10 0 15p
RRG    RG 0 1G
RRG10  RG10 0 1G
RISO   OUT OUTA 47
COUT   OUTA JACK 4.7u
RBLEED JACK 0 220k
RLOAD  JACK 0 100k
.control
noise v(JACK) VSRC lin 2 1000 1001 1
setplot noise1
print all
* --- wrdata (L4) -----------------------------------------------------
* DOVE: plot `noise1`. Un'analisi `noise` ne produce DUE - noise1
* (densita' spettrale) e noise2 (integrato) - e il `setplot` qui sopra
* decide quale si scrive. Vale docs/limitations.md #10.
*
* PERCHE' noise2 NON viene scritto: la banda di questo deck e' larga 1 Hz
* per costruzione (lin 2 1000 1001), quindi il rumore integrato che ne
* esce non significa niente. La cifra integrata e' di
* tb_noise_breakdown.cir, non di questo deck.
*
* PERCHE' NON `wrdata ... all`: `print all` qui elenca 172 vettori, cioe'
* 344 colonne intestate col0..col343 - un file che nessuno puo' piu'
* interpretare. Si scrivono i due totali piu' i contributori dominanti,
* e SOLO i totali per dispositivo (mai onoise_q121b_rb accanto a
* onoise_q121b: sarebbe contato due volte). La somma in quadratura di TUTTI
* i totali per dispositivo e' onoise_spectrum; quanto ne portano gli otto
* scritti qui lo misura docs/preamp/data/2026-09-15/L31/esplorazione/
* script/riscontro.py.
*
* I NOMI (L31, NC-030). Da L22 a L31 questa riga citava onoise_q123,
* onoise_r121, onoise_jq110 e onoise_jq111, dispositivi che non esistevano
* piu': "Error: no such vector", il wrdata si fermava, nessun dato, rc 0.
* E tre nomi VIVI erano gia' sbagliati (limitations #22, secondo modo):
* onoise_q122, onoise_r120 e onoise_r138, scritti in L4 per il diodo dello
* specchio, la sua degenerazione e R_f, oggi sono il VAS, l'altra
* degenerazione e R_g. I nomi qui sotto vengono da una mappa per NODI
* dall'include di L4 a quello di oggi (L31/esplorazione/mappa.txt), non da
* un elenco: se il blocco si rinumera, si rifa' la mappa.
*   specchio, uscita    NHI NMIRI NME2   q123  -> q121b
*   specchio, diodo     NMIRI NMIRI NME1 q122  -> q121a
*   R_f                 OUT FB           r138  -> r136
*   degenerazione usc.  VPLUS NME2       r121  -> r120
*   degenerazione diodo VPLUS NME1       r120  -> r119
*   sorgente            SRCN IN          rsrc
*   coppia d'ingresso   D1N G1 S1 / D2N G2 S2   jq110 / jq111 -> jq110a / jq110b
* Il blocco 2g di run_tests.sh ora rifiuta un onoise_<dispositivo> morto;
* un nome vivo sbagliato continua a non vederlo.
*
* COLONNE: 2 righe (1000 e 1001 Hz) e, per ogni vettore, una COPPIA
* (frequenza, valore). Le colonne PARI sono la frequenza ripetuta; i dati
* sono le DISPARI, in quest'ordine:
*   col1 onoise_spectrum   col3 inoise_spectrum   col5 onoise_q121b
*   col7 onoise_q121a      col9 onoise_r136      col11 onoise_r120
*  col13 onoise_r119      col15 onoise_rsrc      col17 onoise_jq110a
*  col19 onoise_jq110b
*
* ATTENZIONE: sono numeri da MODELLI SEGNAPOSTO, con KF = 0: un pavimento
* senza rumore 1/f (NC-004, NC-031). Non sono una cifra di rumore
* credibile e non vanno nel dossier.
* ---------------------------------------------------------------------
wrdata tb_noise_vectors_wrdata.txt onoise_spectrum inoise_spectrum onoise_q121b onoise_q121a onoise_r136 onoise_r120 onoise_r119 onoise_rsrc onoise_jq110a onoise_jq110b
.endc
.end
