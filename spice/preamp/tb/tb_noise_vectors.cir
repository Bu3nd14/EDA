tb_noise_vectors.cir - list the per-device noise vectors ngspice keeps
.include @REPO@/spice/preamp/placeholder_devices.lib
.include @REPO@/spice/preamp/gain_block_flat.inc
VPP VPLUS 0 DC 15
VMM VMINUS 0 DC -15
VSRC SRCN 0 DC 0 AC 1
RSRC SRCN IN 430
CSTRAY RG 0 15p
RRG    RG 0 1G
RISO   OUT OUTA 47
COUT   OUTA JACK 4.7u
RBLEED JACK 0 220k
RLOAD  JACK 0 100k
.control
noise v(JACK) VSRC lin 2 1000 1001 1
setplot noise1
print all
.endc
.end
