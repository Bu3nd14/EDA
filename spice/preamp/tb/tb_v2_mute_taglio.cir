tb_v2_mute_taglio.cir - V2 al jack col mute che taglia coi soli rele' al jack (ADR-062, L47c2b1; fino a L47c2a tb_v2_mute_ldr.cir, con le fotoresistenze)
* Prima riga = titolo (docs/limitations.md #10).
* GENERATO da docs/preamp/data/2026-09-22/L29b2/deck/genera_tb_v2_mute_taglio.py: non si
* edita a mano. L'intestazione del generatore dice cosa c'e' dentro e come si corre.
*
* Da L39 (NC-017) ogni dispositivo attivo e' il modello del costruttore in models/, e da L44
* tutti hanno KF (1/f; ADR-057).
*
* IL MUTE e' il contatto del blocco al jack (geometria N), 24 ms dopo il tasto (MUTE_CMD 21 ms
* del firmware di L47c2a, piu' 3 ms del G6K); al rilascio lo stesso. La geometria iii del
* sorgente e' in tb_v2_casopeggiore.cir.
*
* TEMPI: tasto del mute a 1 s, contatto a 1.024 s, tasto del rilascio a 2 s, fine a 5 s.
* Tono 2,7 V RMS, +10 dB, fase pi/2.
*
* ANALISI: scripts/v2_metodo.py analizza sul manifesto (tabella echo, nome
* tb_v2_mute_taglio_manifest.csv; nessun wrdata lo nomina, #25). t_grad = 24 ms.
* CONVENZIONE DI PERCORSO: `.include @REPO@/...` (tb_op.cir, L2-L3).

.include @REPO@/models/jfet/lsk489.lib
.include @REPO@/models/bjt_npn/mmbt5551.lib
.include @REPO@/models/bjt_pnp/mmbt5401.lib
.include @REPO@/models/bjt_npn/mje15032.lib
.include @REPO@/models/bjt_pnp/mje15033.lib
.include @REPO@/models/diodes/1n4148.lib
.include @REPO@/models/bjt_pnp/ls350.lib
.include @REPO@/spice/preamp/gain_block.subckt

* >>> CANALE - identico nei tre deck tb_v2_mute_*.cir (v2_metodo.py canale)
* TOLLERANZE (L29a, ripresa 2026-09-16): vedi il blocco esteso in
* tb_v2_mute_varianti.cir. vntol=1e-9 rendeva il deck non eseguibile (41 ore
* per una cella senza segnale); vntol=1e-6 la fa in 5,5 s e le cifre non
* cambiano - verificato, data/2026-09-16/L29a/tolleranze/.
.options reltol=1e-6 vntol=1e-6 abstol=1e-12
VPP VPLUS 0 DC 15
VMM VMINUS 0 DC -15

* ---- sorgente con inviluppo d'entrata ----
VAMP NAMP 0 DC 3.818
VFRQ NFRQ 0 DC 1000
VPHS NPHS 0 DC 0
VTEN NTEN 0 DC 0.3
BSRC SRC 0 V = V(NAMP) * sin(6.283185307179586*V(NFRQ)*time + V(NPHS))
+ * (0.5 - 0.5*cos(3.141592653589793*min(time/V(NTEN), 1)))
RSRC SRC SELA 1.5

* ---- stati dei contatti: t_ins, t_rel, durata graduale, netto(1)/graduale(0) ----
VTIJK NTIJK 0 DC 1000
VTRJK NTRJK 0 DC 2000
VTGJK NTGJK 0 DC 1
VMHJK NMHJK 0 DC 1
BSJKR SJKR 0 V = V(NMHJK)
+ * pwl(time - V(NTIJK), -1e4,0, 0,0, 1u,1, 150u,1, 151u,0, 300u,0, 301u,1, 450u,1, 451u,0, 520u,0, 521u,1, 1e4,1)
+ * pwl(time - V(NTRJK), -1e4,1, 0,1, 1u,0, 400u,0, 401u,1, 600u,1, 601u,0, 1e4,0)
+ + (1 - V(NMHJK)) * min(max((time - V(NTIJK))/V(NTGJK), 0), 1)
+ * (1 - min(max((time - V(NTRJK))/V(NTGJK), 0), 1))
RSJK SJKR SJK 1k
CSJK SJK 0 4.55n
VTIPRE NTIPRE 0 DC 1000
VTRPRE NTRPRE 0 DC 2000
VTGPRE NTGPRE 0 DC 1
VMHPRE NMHPRE 0 DC 1
BSPRER SPRER 0 V = V(NMHPRE)
+ * pwl(time - V(NTIPRE), -1e4,0, 0,0, 1u,1, 150u,1, 151u,0, 300u,0, 301u,1, 450u,1, 451u,0, 520u,0, 521u,1, 1e4,1)
+ * pwl(time - V(NTRPRE), -1e4,1, 0,1, 1u,0, 400u,0, 401u,1, 600u,1, 601u,0, 1e4,0)
+ + (1 - V(NMHPRE)) * min(max((time - V(NTIPRE))/V(NTGPRE), 0), 1)
+ * (1 - min(max((time - V(NTRPRE))/V(NTGPRE), 0), 1))
RSPRE SPRER SPRE 1k
CSPRE SPRE 0 4.55n
VTISER NTISER 0 DC 1000
VTRSER NTRSER 0 DC 2000
VTGSER NTGSER 0 DC 1
VMHSER NMHSER 0 DC 1
BSSERR SSERR 0 V = V(NMHSER)
+ * pwl(time - V(NTISER), -1e4,0, 0,0, 1u,1, 150u,1, 151u,0, 300u,0, 301u,1, 450u,1, 451u,0, 520u,0, 521u,1, 1e4,1)
+ * pwl(time - V(NTRSER), -1e4,1, 0,1, 1u,0, 400u,0, 401u,1, 600u,1, 601u,0, 1e4,0)
+ + (1 - V(NMHSER)) * min(max((time - V(NTISER))/V(NTGSER), 0), 1)
+ * (1 - min(max((time - V(NTRSER))/V(NTGSER), 0), 1))
RSSER SSERR SSER 1k
CSSER SSER 0 4.55n
VTISEL NTISEL 0 DC 1000
VTRSEL NTRSEL 0 DC 2000
VTGSEL NTGSEL 0 DC 1
VMHSEL NMHSEL 0 DC 1
BSSELR SSELR 0 V = V(NMHSEL)
+ * pwl(time - V(NTISEL), -1e4,0, 0,0, 1u,1, 150u,1, 151u,0, 300u,0, 301u,1, 450u,1, 451u,0, 520u,0, 521u,1, 1e4,1)
+ * pwl(time - V(NTRSEL), -1e4,1, 0,1, 1u,0, 400u,0, 401u,1, 600u,1, 601u,0, 1e4,0)
+ + (1 - V(NMHSEL)) * min(max((time - V(NTISEL))/V(NTGSEL), 0), 1)
+ * (1 - min(max((time - V(NTRSEL))/V(NTGSEL), 0), 1))
RSSEL SSELR SSEL 1k
CSSEL SSEL 0 4.55n

* ---- selettore d'ingresso: serie, s = 1 vuol dire APERTO ----
BSEL SELA INA I = V(SELA,INA) * pow(10, -12 + 13*(1 - V(SSEL)))

* ---------------- BLOCCO A: guadagno 1, R_g non montata ------------------
VOSA INA INAX DC 0
XA INAX OUTA FBA RGA RG10A VPLUS VMINUS GAINBLOCK
RRGA RGA 0 1G
CRGA RGA 0 15p
RRG10A RG10A 0 1G
CRG10A RG10A 0 15p

* Attenuatore da 10 k: RATTT a 1 mohm = manopola al massimo.
RATTT OUTA W 1m
RATTB W 0 10k

* ---------------- BUFFER DELLE FISSE (ADR-023): guadagno 1 ---------------
VOSF1 OUTA F1IN DC 0
XF1 F1IN OUTF1 FBF1 RGF1 RG10F1 VPLUS VMINUS GAINBLOCK
RRGF1 RGF1 0 1G
CRGF1 RGF1 0 15p
RRG10F1 RG10F1 0 1G
CRG10F1 RG10F1 0 15p
VOSF2 OUTA F2IN DC 0
XF2 F2IN OUTF2 FBF2 RGF2 RG10F2 VPLUS VMINUS GAINBLOCK
RRGF2 RGF2 0 1G
CRGF2 RGF2 0 15p
RRG10F2 RG10F2 0 1G
CRG10F2 RG10F2 0 15p

RSEP1 OUTF1 FIX1 47
BPRE1 FIX1 0 I = V(FIX1) * pow(10, -12 + 13*V(SPRE))
CFIX1 FIX1 FIXC1 4.7u
RBC1 FIXC1 0 1e12
RBY1 FIXC1 FIXJACK1 1m
BSER1 FIXC1 FIXJACK1 I = V(FIXC1,FIXJACK1) * pow(10, -12 + 13*(1 - V(SSER)))
BJK1 FIXJACK1 0 I = V(FIXJACK1) * pow(10, -12 + 13*V(SJK))
RBL1 FIXJACK1 0 470k
RLD1 FIXJACK1 0 100k

RSEP2 OUTF2 FIX2 47
BPRE2 FIX2 0 I = V(FIX2) * pow(10, -12 + 13*V(SPRE))
CFIX2 FIX2 FIXC2 4.7u
RBC2 FIXC2 0 1e12
RBY2 FIXC2 FIXJACK2 1m
BSER2 FIXC2 FIXJACK2 I = V(FIXC2,FIXJACK2) * pow(10, -12 + 13*(1 - V(SSER)))
BJK2 FIXJACK2 0 I = V(FIXJACK2) * pow(10, -12 + 13*V(SJK))
RBL2 FIXJACK2 0 470k
RLD2 FIXJACK2 0 100k

* ---------------- BLOCCO B: 0 / +3 / +10 dB, due rele' su R_g ------------
* Contatto aperto = 1 G + 15 pF, chiuso = alter ... = 0.1 (ADR-026):
*   0 dB   rrgb = 1G    rrg10b = 1G
*   +3 dB  rrgb = 0.1   rrg10b = 1G
*   +10 dB rrgb = 0.1   rrg10b = 0.1
VOSB W WB DC 0
XB WB OUTB FBB RGB RG10B VPLUS VMINUS GAINBLOCK
RRGB RGB 0 1G
CRGB RGB 0 15p
RRG10B RG10B 0 1G
CRG10B RG10B 0 15p
RISOM OUTB MAIN_A 47
BPREM MAIN_A 0 I = V(MAIN_A) * pow(10, -12 + 13*V(SPRE))
COUTM MAIN_A MAINC 4.7u
RBCM MAINC 0 1e12
RBYM MAINC MAINJACK 1m
BSERM MAINC MAINJACK I = V(MAINC,MAINJACK) * pow(10, -12 + 13*(1 - V(SSER)))
BJKM MAINJACK 0 I = V(MAINJACK) * pow(10, -12 + 13*V(SJK))
RBLM MAINJACK 0 220k
RLDM MAINJACK 0 100k
* <<< CANALE

.control
* limitations #30: il tempo a 16 cifre, prima di ogni wrdata
set numdgt=15
set d = .dat
save v(mainjack) v(fixjack1) v(fixjack2) v(ina)
echo "cella,file,variante,f_hz,amp,gm,rl,t_ins,t_rel,t_fine,tmax,tipo,rif_ins,rif_rel,t_grad" > tb_v2_mute_taglio_manifest.csv
alter rrgb = 0.1
alter rrg10b = 0.1
alter vphs dc = 1.5707963267948966
alter vmhjk dc = 1
* ======== carico 100k su tutte e tre le uscite ========
alter rldm = 100k
alter rld1 = 100k
alter rld2 = 100k
* ---- 20 Hz, 100k ----
alter vamp dc = 3.818
alter vfrq dc = 20
alter vtijk dc = 1000.000000
alter vtrjk dc = 2000.000000
tran 1e-05 5.0 0 1e-05
wrdata mai_20_100k$d v(mainjack) v(fixjack1) v(fixjack2)
destroy all
echo "mai_20_100k,mai_20_100k.dat,rif,20,3.818,10,100k,1.0,2.0,5.0,1e-05,rif_mai,-,-,0.0" >> tb_v2_mute_taglio_manifest.csv
alter vamp dc = 3.818
alter vfrq dc = 20
alter vtijk dc = -10.000000
alter vtrjk dc = 1000.000000
tran 1e-05 5.0 0 1e-05
wrdata sempre_20_100k$d v(mainjack) v(fixjack1) v(fixjack2)
destroy all
echo "sempre_20_100k,sempre_20_100k.dat,rif,20,3.818,10,100k,1.0,2.0,5.0,1e-05,rif_sempre,-,-,0.0" >> tb_v2_mute_taglio_manifest.csv
alter vamp dc = 3.818
alter vfrq dc = 20
alter vtijk dc = 1.024000
alter vtrjk dc = 2.024000
tran 1e-05 5.0 0 1e-05
wrdata ev_20_100k$d v(mainjack) v(fixjack1) v(fixjack2)
wrdata ev_20_100k_stati$d v(ina)
destroy all
echo "ev_20_100k,ev_20_100k.dat,taglio,20,3.818,10,100k,1.0,2.0,5.0,1e-05,evento,sempre_20_100k,mai_20_100k,0.024" >> tb_v2_mute_taglio_manifest.csv
alter vamp dc = 3.818
alter vfrq dc = 20
alter vtijk dc = 1.024000
alter vtrjk dc = 2.024000
tran 7e-06 5.0 0 7e-06
wrdata evp_20_100k$d v(mainjack) v(fixjack1) v(fixjack2)
destroy all
echo "pav_ev0_20_100k,evp_20_100k.dat,pavimento,20,3.818,10,100k,1.0,1000,5.0,7e-06,pav_num,ev_20_100k,-,0.0" >> tb_v2_mute_taglio_manifest.csv
echo "pav_ev1_20_100k,evp_20_100k.dat,pavimento,20,3.818,10,100k,2.0,1000,5.0,7e-06,pav_num,ev_20_100k,-,0.0" >> tb_v2_mute_taglio_manifest.csv
* ---- 1000 Hz, 100k ----
alter vamp dc = 3.818
alter vfrq dc = 1000
alter vtijk dc = 1000.000000
alter vtrjk dc = 2000.000000
tran 1e-05 5.0 0 1e-05
wrdata mai_1k_100k$d v(mainjack) v(fixjack1) v(fixjack2)
destroy all
echo "mai_1k_100k,mai_1k_100k.dat,rif,1000,3.818,10,100k,1.0,2.0,5.0,1e-05,rif_mai,-,-,0.0" >> tb_v2_mute_taglio_manifest.csv
alter vamp dc = 3.818
alter vfrq dc = 1000
alter vtijk dc = -10.000000
alter vtrjk dc = 1000.000000
tran 1e-05 5.0 0 1e-05
wrdata sempre_1k_100k$d v(mainjack) v(fixjack1) v(fixjack2)
destroy all
echo "sempre_1k_100k,sempre_1k_100k.dat,rif,1000,3.818,10,100k,1.0,2.0,5.0,1e-05,rif_sempre,-,-,0.0" >> tb_v2_mute_taglio_manifest.csv
alter vamp dc = 3.818
alter vfrq dc = 1000
alter vtijk dc = 1.024000
alter vtrjk dc = 2.024000
tran 1e-05 5.0 0 1e-05
wrdata ev_1k_100k$d v(mainjack) v(fixjack1) v(fixjack2)
wrdata ev_1k_100k_stati$d v(ina)
destroy all
echo "ev_1k_100k,ev_1k_100k.dat,taglio,1000,3.818,10,100k,1.0,2.0,5.0,1e-05,evento,sempre_1k_100k,mai_1k_100k,0.024" >> tb_v2_mute_taglio_manifest.csv
alter vamp dc = 3.818
alter vfrq dc = 1000
alter vtijk dc = 1.024000
alter vtrjk dc = 2.024000
tran 7e-06 5.0 0 7e-06
wrdata evp_1k_100k$d v(mainjack) v(fixjack1) v(fixjack2)
destroy all
echo "pav_ev0_1k_100k,evp_1k_100k.dat,pavimento,1000,3.818,10,100k,1.0,1000,5.0,7e-06,pav_num,ev_1k_100k,-,0.0" >> tb_v2_mute_taglio_manifest.csv
echo "pav_ev1_1k_100k,evp_1k_100k.dat,pavimento,1000,3.818,10,100k,2.0,1000,5.0,7e-06,pav_num,ev_1k_100k,-,0.0" >> tb_v2_mute_taglio_manifest.csv
* ---- 20000 Hz, 100k ----
alter vamp dc = 3.818
alter vfrq dc = 20000
alter vtijk dc = 1000.000000
alter vtrjk dc = 2000.000000
tran 5e-07 5.0 0 5e-07
wrdata mai_20k_100k$d v(mainjack) v(fixjack1) v(fixjack2)
destroy all
echo "mai_20k_100k,mai_20k_100k.dat,rif,20000,3.818,10,100k,1.0,2.0,5.0,5e-07,rif_mai,-,-,0.0" >> tb_v2_mute_taglio_manifest.csv
alter vamp dc = 3.818
alter vfrq dc = 20000
alter vtijk dc = -10.000000
alter vtrjk dc = 1000.000000
tran 5e-07 5.0 0 5e-07
wrdata sempre_20k_100k$d v(mainjack) v(fixjack1) v(fixjack2)
destroy all
echo "sempre_20k_100k,sempre_20k_100k.dat,rif,20000,3.818,10,100k,1.0,2.0,5.0,5e-07,rif_sempre,-,-,0.0" >> tb_v2_mute_taglio_manifest.csv
alter vamp dc = 3.818
alter vfrq dc = 20000
alter vtijk dc = 1.024000
alter vtrjk dc = 2.024000
tran 5e-07 5.0 0 5e-07
wrdata ev_20k_100k$d v(mainjack) v(fixjack1) v(fixjack2)
wrdata ev_20k_100k_stati$d v(ina)
destroy all
echo "ev_20k_100k,ev_20k_100k.dat,taglio,20000,3.818,10,100k,1.0,2.0,5.0,5e-07,evento,sempre_20k_100k,mai_20k_100k,0.024" >> tb_v2_mute_taglio_manifest.csv
alter vamp dc = 3.818
alter vfrq dc = 20000
alter vtijk dc = 1.024000
alter vtrjk dc = 2.024000
tran 3.5e-07 5.0 0 3.5e-07
wrdata evp_20k_100k$d v(mainjack) v(fixjack1) v(fixjack2)
destroy all
echo "pav_ev0_20k_100k,evp_20k_100k.dat,pavimento,20000,3.818,10,100k,1.0,1000,5.0,3.5e-07,pav_num,ev_20k_100k,-,0.0" >> tb_v2_mute_taglio_manifest.csv
echo "pav_ev1_20k_100k,evp_20k_100k.dat,pavimento,20000,3.818,10,100k,2.0,1000,5.0,3.5e-07,pav_num,ev_20k_100k,-,0.0" >> tb_v2_mute_taglio_manifest.csv
* ---- A senza segnale, 100k ----
alter vamp dc = 0
alter vfrq dc = 1000
alter vtijk dc = 1000.000000
alter vtrjk dc = 2000.000000
tran 1e-05 5.0 0 1e-05
wrdata lzmai_100k$d v(mainjack) v(fixjack1) v(fixjack2)
destroy all
echo "lzmai_100k,lzmai_100k.dat,rif,1000,0,10,100k,1.0,2.0,5.0,1e-05,rif_mai,-,-,0.0" >> tb_v2_mute_taglio_manifest.csv
alter vamp dc = 0
alter vfrq dc = 1000
alter vtijk dc = -10.000000
alter vtrjk dc = 1000.000000
tran 1e-05 5.0 0 1e-05
wrdata lzsempre_100k$d v(mainjack) v(fixjack1) v(fixjack2)
destroy all
echo "lzsempre_100k,lzsempre_100k.dat,rif,1000,0,10,100k,1.0,2.0,5.0,1e-05,rif_sempre,-,-,0.0" >> tb_v2_mute_taglio_manifest.csv
alter vamp dc = 0
alter vfrq dc = 1000
alter vtijk dc = 1.024000
alter vtrjk dc = 2.024000
tran 1e-05 5.0 0 1e-05
wrdata lzev_100k$d v(mainjack) v(fixjack1) v(fixjack2)
wrdata lzev_100k_stati$d v(ina)
destroy all
echo "lzev_100k,lzev_100k.dat,taglio,1000,0,10,100k,1.0,2.0,5.0,1e-05,evento,lzsempre_100k,lzmai_100k,0.024" >> tb_v2_mute_taglio_manifest.csv
* ======== carico 10k su tutte e tre le uscite ========
alter rldm = 10k
alter rld1 = 10k
alter rld2 = 10k
* ---- 20 Hz, 10k ----
alter vamp dc = 3.818
alter vfrq dc = 20
alter vtijk dc = 1000.000000
alter vtrjk dc = 2000.000000
tran 1e-05 5.0 0 1e-05
wrdata mai_20_10k$d v(mainjack) v(fixjack1) v(fixjack2)
destroy all
echo "mai_20_10k,mai_20_10k.dat,rif,20,3.818,10,10k,1.0,2.0,5.0,1e-05,rif_mai,-,-,0.0" >> tb_v2_mute_taglio_manifest.csv
alter vamp dc = 3.818
alter vfrq dc = 20
alter vtijk dc = -10.000000
alter vtrjk dc = 1000.000000
tran 1e-05 5.0 0 1e-05
wrdata sempre_20_10k$d v(mainjack) v(fixjack1) v(fixjack2)
destroy all
echo "sempre_20_10k,sempre_20_10k.dat,rif,20,3.818,10,10k,1.0,2.0,5.0,1e-05,rif_sempre,-,-,0.0" >> tb_v2_mute_taglio_manifest.csv
alter vamp dc = 3.818
alter vfrq dc = 20
alter vtijk dc = 1.024000
alter vtrjk dc = 2.024000
tran 1e-05 5.0 0 1e-05
wrdata ev_20_10k$d v(mainjack) v(fixjack1) v(fixjack2)
wrdata ev_20_10k_stati$d v(ina)
destroy all
echo "ev_20_10k,ev_20_10k.dat,taglio,20,3.818,10,10k,1.0,2.0,5.0,1e-05,evento,sempre_20_10k,mai_20_10k,0.024" >> tb_v2_mute_taglio_manifest.csv
alter vamp dc = 3.818
alter vfrq dc = 20
alter vtijk dc = 1.024000
alter vtrjk dc = 2.024000
tran 7e-06 5.0 0 7e-06
wrdata evp_20_10k$d v(mainjack) v(fixjack1) v(fixjack2)
destroy all
echo "pav_ev0_20_10k,evp_20_10k.dat,pavimento,20,3.818,10,10k,1.0,1000,5.0,7e-06,pav_num,ev_20_10k,-,0.0" >> tb_v2_mute_taglio_manifest.csv
echo "pav_ev1_20_10k,evp_20_10k.dat,pavimento,20,3.818,10,10k,2.0,1000,5.0,7e-06,pav_num,ev_20_10k,-,0.0" >> tb_v2_mute_taglio_manifest.csv
* ---- 1000 Hz, 10k ----
alter vamp dc = 3.818
alter vfrq dc = 1000
alter vtijk dc = 1000.000000
alter vtrjk dc = 2000.000000
tran 1e-05 5.0 0 1e-05
wrdata mai_1k_10k$d v(mainjack) v(fixjack1) v(fixjack2)
destroy all
echo "mai_1k_10k,mai_1k_10k.dat,rif,1000,3.818,10,10k,1.0,2.0,5.0,1e-05,rif_mai,-,-,0.0" >> tb_v2_mute_taglio_manifest.csv
alter vamp dc = 3.818
alter vfrq dc = 1000
alter vtijk dc = -10.000000
alter vtrjk dc = 1000.000000
tran 1e-05 5.0 0 1e-05
wrdata sempre_1k_10k$d v(mainjack) v(fixjack1) v(fixjack2)
destroy all
echo "sempre_1k_10k,sempre_1k_10k.dat,rif,1000,3.818,10,10k,1.0,2.0,5.0,1e-05,rif_sempre,-,-,0.0" >> tb_v2_mute_taglio_manifest.csv
alter vamp dc = 3.818
alter vfrq dc = 1000
alter vtijk dc = 1.024000
alter vtrjk dc = 2.024000
tran 1e-05 5.0 0 1e-05
wrdata ev_1k_10k$d v(mainjack) v(fixjack1) v(fixjack2)
wrdata ev_1k_10k_stati$d v(ina)
destroy all
echo "ev_1k_10k,ev_1k_10k.dat,taglio,1000,3.818,10,10k,1.0,2.0,5.0,1e-05,evento,sempre_1k_10k,mai_1k_10k,0.024" >> tb_v2_mute_taglio_manifest.csv
alter vamp dc = 3.818
alter vfrq dc = 1000
alter vtijk dc = 1.024000
alter vtrjk dc = 2.024000
tran 7e-06 5.0 0 7e-06
wrdata evp_1k_10k$d v(mainjack) v(fixjack1) v(fixjack2)
destroy all
echo "pav_ev0_1k_10k,evp_1k_10k.dat,pavimento,1000,3.818,10,10k,1.0,1000,5.0,7e-06,pav_num,ev_1k_10k,-,0.0" >> tb_v2_mute_taglio_manifest.csv
echo "pav_ev1_1k_10k,evp_1k_10k.dat,pavimento,1000,3.818,10,10k,2.0,1000,5.0,7e-06,pav_num,ev_1k_10k,-,0.0" >> tb_v2_mute_taglio_manifest.csv
* ---- 20000 Hz, 10k ----
alter vamp dc = 3.818
alter vfrq dc = 20000
alter vtijk dc = 1000.000000
alter vtrjk dc = 2000.000000
tran 5e-07 5.0 0 5e-07
wrdata mai_20k_10k$d v(mainjack) v(fixjack1) v(fixjack2)
destroy all
echo "mai_20k_10k,mai_20k_10k.dat,rif,20000,3.818,10,10k,1.0,2.0,5.0,5e-07,rif_mai,-,-,0.0" >> tb_v2_mute_taglio_manifest.csv
alter vamp dc = 3.818
alter vfrq dc = 20000
alter vtijk dc = -10.000000
alter vtrjk dc = 1000.000000
tran 5e-07 5.0 0 5e-07
wrdata sempre_20k_10k$d v(mainjack) v(fixjack1) v(fixjack2)
destroy all
echo "sempre_20k_10k,sempre_20k_10k.dat,rif,20000,3.818,10,10k,1.0,2.0,5.0,5e-07,rif_sempre,-,-,0.0" >> tb_v2_mute_taglio_manifest.csv
alter vamp dc = 3.818
alter vfrq dc = 20000
alter vtijk dc = 1.024000
alter vtrjk dc = 2.024000
tran 5e-07 5.0 0 5e-07
wrdata ev_20k_10k$d v(mainjack) v(fixjack1) v(fixjack2)
wrdata ev_20k_10k_stati$d v(ina)
destroy all
echo "ev_20k_10k,ev_20k_10k.dat,taglio,20000,3.818,10,10k,1.0,2.0,5.0,5e-07,evento,sempre_20k_10k,mai_20k_10k,0.024" >> tb_v2_mute_taglio_manifest.csv
alter vamp dc = 3.818
alter vfrq dc = 20000
alter vtijk dc = 1.024000
alter vtrjk dc = 2.024000
tran 3.5e-07 5.0 0 3.5e-07
wrdata evp_20k_10k$d v(mainjack) v(fixjack1) v(fixjack2)
destroy all
echo "pav_ev0_20k_10k,evp_20k_10k.dat,pavimento,20000,3.818,10,10k,1.0,1000,5.0,3.5e-07,pav_num,ev_20k_10k,-,0.0" >> tb_v2_mute_taglio_manifest.csv
echo "pav_ev1_20k_10k,evp_20k_10k.dat,pavimento,20000,3.818,10,10k,2.0,1000,5.0,3.5e-07,pav_num,ev_20k_10k,-,0.0" >> tb_v2_mute_taglio_manifest.csv
* ---- A senza segnale, 10k ----
alter vamp dc = 0
alter vfrq dc = 1000
alter vtijk dc = 1000.000000
alter vtrjk dc = 2000.000000
tran 1e-05 5.0 0 1e-05
wrdata lzmai_10k$d v(mainjack) v(fixjack1) v(fixjack2)
destroy all
echo "lzmai_10k,lzmai_10k.dat,rif,1000,0,10,10k,1.0,2.0,5.0,1e-05,rif_mai,-,-,0.0" >> tb_v2_mute_taglio_manifest.csv
alter vamp dc = 0
alter vfrq dc = 1000
alter vtijk dc = -10.000000
alter vtrjk dc = 1000.000000
tran 1e-05 5.0 0 1e-05
wrdata lzsempre_10k$d v(mainjack) v(fixjack1) v(fixjack2)
destroy all
echo "lzsempre_10k,lzsempre_10k.dat,rif,1000,0,10,10k,1.0,2.0,5.0,1e-05,rif_sempre,-,-,0.0" >> tb_v2_mute_taglio_manifest.csv
alter vamp dc = 0
alter vfrq dc = 1000
alter vtijk dc = 1.024000
alter vtrjk dc = 2.024000
tran 1e-05 5.0 0 1e-05
wrdata lzev_10k$d v(mainjack) v(fixjack1) v(fixjack2)
wrdata lzev_10k_stati$d v(ina)
destroy all
echo "lzev_10k,lzev_10k.dat,taglio,1000,0,10,10k,1.0,2.0,5.0,1e-05,evento,lzsempre_10k,lzmai_10k,0.024" >> tb_v2_mute_taglio_manifest.csv
.endc

.end
