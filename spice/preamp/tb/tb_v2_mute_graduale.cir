tb_v2_mute_graduale.cir - V2 al jack (ADR-032): il rilascio lento e il mute graduale, con un elemento ideale, sulla catena intera (L29a, NC-028)
* Prima riga = titolo (docs/limitations.md #10).
*
* COSA MISURA. Che profilo deve avere un mute graduale per rispettare A, B e C
* al jack. L'elemento e' IDEALE: la conduttanza del canale con NMHx = 0, cioe'
* G = 10^(-12 + 13 s) con s che rampa linearmente in T secondi, quindi G
* log-lineare fra 1e-12 S e 10 S (100 mohm a fine corsa, come il contatto).
* Nessuna tecnica e' scelta: il deck consegna un requisito di profilo, non un
* rimedio. Con G log-lineare l'ampiezza al jack cambia quasi tutta mentre G
* attraversa i ~3 decenni attorno a 1/47 S: la dissolvenza EFFICACE e' circa
* 3/13 di T, e va detto accanto a ogni cifra.
* L'analisi e' scripts/v2_metodo.py analizza; la colonna t_grad del manifesto
* estende la finestra di C e l'inizio di B2 a tutta la rampa.
*
* LE POSIZIONI (indice g nei nomi dei file):
*   g1  graduale al jack (JK), in derivazione dopo il condensatore
*   g2  graduale fra i 47 ohm e il 4,7 uF (PRE), in derivazione prima
*   g3  graduale fra i 47 ohm e il 4,7 uF, con l'offset in continua annullato
*       come v3 di tb_v2_mute_varianti.cir (tre giri di .op, tabella
*       tb_v2_mute_graduale_offset.csv): "contatto prima + offset abbassato +
*       rilascio lento"
*   g4  graduale in serie (SER): aperto a mute inserito, ponte RBYx aperto,
*       bleeder lato condensatore 220 k / 470 k
*
* LE CELLE (per posizione e per carico, 100 k e 10 k su tutte e tre le uscite),
* +10 dB, manopola al massimo, T = 20 ms, 200 ms, 1 s, 3 s:
*   _bmT       CON MUSICA, 2,7 V RMS a 1 kHz, fase pi/2: la rampa d'inserzione
*              parte a 1,0 s; quella di rilascio a 1,0 + T + 0,1 s; la corsa
*              finisce 2 s dopo la fine del rilascio
*   _lzT       SENZA SEGNALE: inserzione a 1,0 s, rilascio a 3,0 + T s, 2 s dopo
*   _bmmai, _bmsempre, _lzmai, _lzsempre   riferimenti, uno per posizione e
*              carico, lunghi quanto la cella piu' lunga
*   _b20       solo 100 k e T = 1 s: la stessa cella con musica a 20 Hz, dove il
*              condensatore si carica di piu' (fase pi/2: 1,0 s e 2,1 s sono
*              periodi interi), coi suoi due riferimenti _b20mai, _b20sempre
*
* MODELLI (L39, NC-017): ogni dispositivo attivo e' il modello del costruttore
* in models/ - LSK489A, MMBT5551, MMBT5401, LS350, Qmje15032, Qmje15033, D1N914.
* Solo l'LSK489A ha KF (1/f); nessun modello porta la dispersione. L'offset
* sistematico e la distorsione, quindi il pavimento di C, dipendono da loro.
*
* CONVENZIONE DI PERCORSO: `.include @REPO@/...` (tb_op.cir, L2-L3) e file
* scritti con nome nudo nella directory d'uscita di run_simulation.sh.

.include @REPO@/models/jfet/lsk489.lib
.include @REPO@/models/bjt_npn/mmbt5551.lib
.include @REPO@/models/bjt_pnp/mmbt5401.lib
.include @REPO@/models/bjt_npn/mje15032.lib
.include @REPO@/models/bjt_pnp/mje15033.lib
.include @REPO@/models/diodes/1n4148.lib
.include @REPO@/models/bjt_pnp/ls350.lib
.include @REPO@/spice/preamp/gain_block.subckt

* >>> CANALE - identico nei tre deck tb_v2_mute_*.cir (v2_metodo.py canale)
* TOLLERANZE (L29a, ripresa 2026-09-16): vedi il blocco esteso in
* tb_v2_mute_varianti.cir. vntol=1e-9 rendeva il deck non eseguibile (41 ore
* per una cella senza segnale); vntol=1e-6 la fa in 5,5 s e le cifre non
* cambiano - verificato, data/2026-09-16/L29a/tolleranze/.
.options reltol=1e-6 vntol=1e-6 abstol=1e-12
VPP VPLUS 0 DC 15
VMM VMINUS 0 DC -15

* ---- sorgente con inviluppo d'entrata ----
VAMP NAMP 0 DC 3.818
VFRQ NFRQ 0 DC 1000
VPHS NPHS 0 DC 0
VTEN NTEN 0 DC 0.3
BSRC SRC 0 V = V(NAMP) * sin(6.283185307179586*V(NFRQ)*time + V(NPHS))
+ * (0.5 - 0.5*cos(3.141592653589793*min(time/V(NTEN), 1)))
RSRC SRC SELA 1.5

* ---- stati dei contatti: t_ins, t_rel, durata graduale, netto(1)/graduale(0) ----
VTIJK NTIJK 0 DC 1000
VTRJK NTRJK 0 DC 2000
VTGJK NTGJK 0 DC 1
VMHJK NMHJK 0 DC 1
BSJKR SJKR 0 V = V(NMHJK)
+ * pwl(time - V(NTIJK), -1e4,0, 0,0, 1u,1, 150u,1, 151u,0, 300u,0, 301u,1, 450u,1, 451u,0, 520u,0, 521u,1, 1e4,1)
+ * pwl(time - V(NTRJK), -1e4,1, 0,1, 1u,0, 400u,0, 401u,1, 600u,1, 601u,0, 1e4,0)
+ + (1 - V(NMHJK)) * min(max((time - V(NTIJK))/V(NTGJK), 0), 1)
+ * (1 - min(max((time - V(NTRJK))/V(NTGJK), 0), 1))
RSJK SJKR SJK 1k
CSJK SJK 0 4.55n
VTIPRE NTIPRE 0 DC 1000
VTRPRE NTRPRE 0 DC 2000
VTGPRE NTGPRE 0 DC 1
VMHPRE NMHPRE 0 DC 1
BSPRER SPRER 0 V = V(NMHPRE)
+ * pwl(time - V(NTIPRE), -1e4,0, 0,0, 1u,1, 150u,1, 151u,0, 300u,0, 301u,1, 450u,1, 451u,0, 520u,0, 521u,1, 1e4,1)
+ * pwl(time - V(NTRPRE), -1e4,1, 0,1, 1u,0, 400u,0, 401u,1, 600u,1, 601u,0, 1e4,0)
+ + (1 - V(NMHPRE)) * min(max((time - V(NTIPRE))/V(NTGPRE), 0), 1)
+ * (1 - min(max((time - V(NTRPRE))/V(NTGPRE), 0), 1))
RSPRE SPRER SPRE 1k
CSPRE SPRE 0 4.55n
VTISER NTISER 0 DC 1000
VTRSER NTRSER 0 DC 2000
VTGSER NTGSER 0 DC 1
VMHSER NMHSER 0 DC 1
BSSERR SSERR 0 V = V(NMHSER)
+ * pwl(time - V(NTISER), -1e4,0, 0,0, 1u,1, 150u,1, 151u,0, 300u,0, 301u,1, 450u,1, 451u,0, 520u,0, 521u,1, 1e4,1)
+ * pwl(time - V(NTRSER), -1e4,1, 0,1, 1u,0, 400u,0, 401u,1, 600u,1, 601u,0, 1e4,0)
+ + (1 - V(NMHSER)) * min(max((time - V(NTISER))/V(NTGSER), 0), 1)
+ * (1 - min(max((time - V(NTRSER))/V(NTGSER), 0), 1))
RSSER SSERR SSER 1k
CSSER SSER 0 4.55n
VTISEL NTISEL 0 DC 1000
VTRSEL NTRSEL 0 DC 2000
VTGSEL NTGSEL 0 DC 1
VMHSEL NMHSEL 0 DC 1
BSSELR SSELR 0 V = V(NMHSEL)
+ * pwl(time - V(NTISEL), -1e4,0, 0,0, 1u,1, 150u,1, 151u,0, 300u,0, 301u,1, 450u,1, 451u,0, 520u,0, 521u,1, 1e4,1)
+ * pwl(time - V(NTRSEL), -1e4,1, 0,1, 1u,0, 400u,0, 401u,1, 600u,1, 601u,0, 1e4,0)
+ + (1 - V(NMHSEL)) * min(max((time - V(NTISEL))/V(NTGSEL), 0), 1)
+ * (1 - min(max((time - V(NTRSEL))/V(NTGSEL), 0), 1))
RSSEL SSELR SSEL 1k
CSSEL SSEL 0 4.55n

* ---- selettore d'ingresso: serie, s = 1 vuol dire APERTO ----
BSEL SELA INA I = V(SELA,INA) * pow(10, -12 + 13*(1 - V(SSEL)))

* ---------------- BLOCCO A: guadagno 1, R_g non montata ------------------
VOSA INA INAX DC 0
XA INAX OUTA FBA RGA RG10A VPLUS VMINUS GAINBLOCK
RRGA RGA 0 1G
CRGA RGA 0 15p
RRG10A RG10A 0 1G
CRG10A RG10A 0 15p

* Attenuatore da 10 k: RATTT a 1 mohm = manopola al massimo.
RATTT OUTA W 1m
RATTB W 0 10k

* ---------------- BUFFER DELLE FISSE (ADR-023): guadagno 1 ---------------
VOSF1 OUTA F1IN DC 0
XF1 F1IN OUTF1 FBF1 RGF1 RG10F1 VPLUS VMINUS GAINBLOCK
RRGF1 RGF1 0 1G
CRGF1 RGF1 0 15p
RRG10F1 RG10F1 0 1G
CRG10F1 RG10F1 0 15p
VOSF2 OUTA F2IN DC 0
XF2 F2IN OUTF2 FBF2 RGF2 RG10F2 VPLUS VMINUS GAINBLOCK
RRGF2 RGF2 0 1G
CRGF2 RGF2 0 15p
RRG10F2 RG10F2 0 1G
CRG10F2 RG10F2 0 15p

RSEP1 OUTF1 FIX1 47
BPRE1 FIX1 0 I = V(FIX1) * pow(10, -12 + 13*V(SPRE))
CFIX1 FIX1 FIXC1 4.7u
RBC1 FIXC1 0 1e12
RBY1 FIXC1 FIXJACK1 1m
BSER1 FIXC1 FIXJACK1 I = V(FIXC1,FIXJACK1) * pow(10, -12 + 13*(1 - V(SSER)))
BJK1 FIXJACK1 0 I = V(FIXJACK1) * pow(10, -12 + 13*V(SJK))
RBL1 FIXJACK1 0 470k
RLD1 FIXJACK1 0 100k

RSEP2 OUTF2 FIX2 47
BPRE2 FIX2 0 I = V(FIX2) * pow(10, -12 + 13*V(SPRE))
CFIX2 FIX2 FIXC2 4.7u
RBC2 FIXC2 0 1e12
RBY2 FIXC2 FIXJACK2 1m
BSER2 FIXC2 FIXJACK2 I = V(FIXC2,FIXJACK2) * pow(10, -12 + 13*(1 - V(SSER)))
BJK2 FIXJACK2 0 I = V(FIXJACK2) * pow(10, -12 + 13*V(SJK))
RBL2 FIXJACK2 0 470k
RLD2 FIXJACK2 0 100k

* ---------------- BLOCCO B: 0 / +3 / +10 dB, due rele' su R_g ------------
* Contatto aperto = 1 G + 15 pF, chiuso = alter ... = 0.1 (ADR-026):
*   0 dB   rrgb = 1G    rrg10b = 1G
*   +3 dB  rrgb = 0.1   rrg10b = 1G
*   +10 dB rrgb = 0.1   rrg10b = 0.1
VOSB W WB DC 0
XB WB OUTB FBB RGB RG10B VPLUS VMINUS GAINBLOCK
RRGB RGB 0 1G
CRGB RGB 0 15p
RRG10B RG10B 0 1G
CRG10B RG10B 0 15p
RISOM OUTB MAIN_A 47
BPREM MAIN_A 0 I = V(MAIN_A) * pow(10, -12 + 13*V(SPRE))
COUTM MAIN_A MAINC 4.7u
RBCM MAINC 0 1e12
RBYM MAINC MAINJACK 1m
BSERM MAINC MAINJACK I = V(MAINC,MAINJACK) * pow(10, -12 + 13*(1 - V(SSER)))
BJKM MAINJACK 0 I = V(MAINJACK) * pow(10, -12 + 13*V(SJK))
RBLM MAINJACK 0 220k
RLDM MAINJACK 0 100k
* <<< CANALE

.control
set d = .dat
* solo i vettori usati: senza, ngspice tiene ogni nodo e una corsa da 7 s supera i GB
save v(mainjack) v(fixjack1) v(fixjack2) v(main_a) v(fix1) v(fix2)
echo "cella,file,variante,f_hz,amp,gm,rl,t_ins,t_rel,t_fine,tmax,tipo,rif_ins,rif_rel,t_grad" > tb_v2_mute_graduale_manifest.csv
echo "blocco,offset_prima_V,offset_dopo_V,compensazione_V" > tb_v2_mute_graduale_offset.csv

* +10 dB, fase pi/2
alter rrgb = 0.1
alter rrg10b = 0.1
alter vphs dc = 1.5707963267948966

* ---- g3: l'offset in continua annullato, tre giri di .op (come v3) ----
op
let x = v(main_a)
set ob0 = "$&x"
let x = v(fix1)
set of10 = "$&x"
let x = v(fix2)
set of20 = "$&x"
let x = v(main_a)/3.148
set scb = "$&x"
let x = v(fix1)
set sc1 = "$&x"
let x = v(fix2)
set sc2 = "$&x"
destroy all
alter vosb dc = $scb
alter vosf1 dc = $sc1
alter vosf2 dc = $sc2
op
let x = $scb + v(main_a)/3.148
set scb = "$&x"
let x = $sc1 + v(fix1)
set sc1 = "$&x"
let x = $sc2 + v(fix2)
set sc2 = "$&x"
destroy all
alter vosb dc = $scb
alter vosf1 dc = $sc1
alter vosf2 dc = $sc2
op
let x = $scb + v(main_a)/3.148
set scb = "$&x"
let x = $sc1 + v(fix1)
set sc1 = "$&x"
let x = $sc2 + v(fix2)
set sc2 = "$&x"
destroy all
alter vosb dc = $scb
alter vosf1 dc = $sc1
alter vosf2 dc = $sc2
op
let x = v(main_a)
set ob1 = "$&x"
let x = v(fix1)
set of11 = "$&x"
let x = v(fix2)
set of21 = "$&x"
echo "MAIN_A,$ob0,$ob1,$scb" >> tb_v2_mute_graduale_offset.csv
echo "FIX1,$of10,$of11,$sc1" >> tb_v2_mute_graduale_offset.csv
echo "FIX2,$of20,$of21,$sc2" >> tb_v2_mute_graduale_offset.csv
destroy all

* kind: 1 bm 20 ms | 2 bm 200 ms | 3 bm 1 s | 4 lz 20 ms | 5 lz 200 ms | 6 lz 1 s
*       7 bmmai | 8 bmsempre | 9 lzmai | 10 lzsempre
*       11 b20 1 s | 12 b20mai | 13 b20sempre   (solo 100 k)
foreach g 1 2 3 4
foreach rlk 100 10
foreach kind 1 2 3 4 5 6 7 8 9 10 11 12 13 14 15
  set salta = 0
* solo le celle a 20 Hz (11,12,13) girano al solo 100 k; 14 e 15 sono le
* rampe da 3 s e vogliono entrambi i carichi come 1..6 (L29a, ripresa)
  if $kind > 10
    if $kind < 14
      if $rlk = 10
        set salta = 1
      end
    end
  end
  if $salta = 0
  * ---- tutto a riposo ----
  alter vtijk dc = 1000
  alter vtrjk dc = 2000
  alter vtipre dc = 1000
  alter vtrpre dc = 2000
  alter vtiser dc = 1000
  alter vtrser dc = 2000
  alter vtisel dc = 1000
  alter vtrsel dc = 2000
  alter vmhjk dc = 1
  alter vmhpre dc = 1
  alter vmhser dc = 1
  alter vtgjk dc = 1
  alter vtgpre dc = 1
  alter vtgser dc = 1
  alter rbym = 1m
  alter rby1 = 1m
  alter rby2 = 1m
  alter rbcm = 1e12
  alter rbc1 = 1e12
  alter rbc2 = 1e12
  alter vosb dc = 0
  alter vosf1 dc = 0
  alter vosf2 dc = 0
  alter vfrq dc = 1000
  if $rlk = 100
    alter rldm = 100k
    alter rld1 = 100k
    alter rld2 = 100k
    set rl = "_100k"
    set rlv = "100k"
  else
    alter rldm = 10k
    alter rld1 = 10k
    alter rld2 = 10k
    set rl = "_10k"
    set rlv = "10k"
  end
  * ---- la cella ----
  set amp = 3.818
  set frq = 1000
  set isev = 0
  set tg = 1
  if $kind = 1
    set tg = 0.02
    set ti = 1.0
    set tr = 1.12
    set tf = 3.14
    set tag = "_bm20ms"
    set sins = "_bmsempre"
    set srel = "_bmmai"
    set isev = 1
  end
  if $kind = 2
    set tg = 0.2
    set ti = 1.0
    set tr = 1.3
    set tf = 3.5
    set tag = "_bm200ms"
    set sins = "_bmsempre"
    set srel = "_bmmai"
    set isev = 1
  end
  if $kind = 3
    set tg = 1.0
    set ti = 1.0
    set tr = 2.1
    set tf = 5.1
    set tag = "_bm1s"
    set sins = "_bmsempre"
    set srel = "_bmmai"
    set isev = 1
  end
  if $kind = 4
    set tg = 0.02
    set amp = 0
    set ti = 1.0
    set tr = 3.02
    set tf = 5.04
    set tag = "_lz20ms"
    set sins = "_lzsempre"
    set srel = "_lzmai"
    set isev = 1
  end
  if $kind = 5
    set tg = 0.2
    set amp = 0
    set ti = 1.0
    set tr = 3.2
    set tf = 5.4
    set tag = "_lz200ms"
    set sins = "_lzsempre"
    set srel = "_lzmai"
    set isev = 1
  end
  if $kind = 6
    set tg = 1.0
    set amp = 0
    set ti = 1.0
    set tr = 4.0
    set tf = 7.0
    set tag = "_lz1s"
    set sins = "_lzsempre"
    set srel = "_lzmai"
    set isev = 1
  end
* i quattro riferimenti sono lunghi quanto la cella piu' lunga che servono:
* con la rampa da 3 s (kind 14/15) _bm* passa da 5,1 a 9,1 s e _lz* da 7,0 a
* 11,0 s. Un riferimento piu' corto della cella troncherebbe la finestra di A
* e di C2 senza dirlo (L29a, ripresa)
  if $kind = 7
    set ti = 1000
    set tr = 2000
    set tf = 9.1
    set tag = "_bmmai"
    set tipo = "rif_mai"
  end
  if $kind = 8
    set ti = -1
    set tr = 1000
    set tf = 9.1
    set tag = "_bmsempre"
    set tipo = "rif_sempre"
  end
  if $kind = 9
    set amp = 0
    set ti = 1000
    set tr = 2000
    set tf = 11.0
    set tag = "_lzmai"
    set tipo = "rif_mai"
  end
  if $kind = 10
    set amp = 0
    set ti = -1
    set tr = 1000
    set tf = 11.0
    set tag = "_lzsempre"
    set tipo = "rif_sempre"
  end
  if $kind = 11
    set tg = 1.0
    set frq = 20
    set ti = 1.0
    set tr = 2.1
    set tf = 5.1
    set tag = "_b20"
    set sins = "_b20sempre"
    set srel = "_b20mai"
    set isev = 1
  end
  if $kind = 12
    set frq = 20
    set ti = 1000
    set tr = 2000
    set tf = 5.1
    set tag = "_b20mai"
    set tipo = "rif_mai"
  end
  if $kind = 13
    set frq = 20
    set ti = -1
    set tr = 1000
    set tf = 5.1
    set tag = "_b20sempre"
    set tipo = "rif_sempre"
  end
* ---- la rampa da 3 s, decisa dall'utente il 2026-09-16 (L29a, ripresa) ----
* Con rampa efficace ~3/13 di T valgono ~700 ms, ancora lontani dai >10 s che
* il fit di C chiederebbe a 1 kHz (caratterizza_C_960.txt): servono a misurare
* la legge 1/T su un quarto punto, non a raggiungere la conformita'.
* Stessa geometria di kind 3 e 6: tr = ti + tg + 0,1 con musica, 3,0 + tg
* senza; tf = tr + tg + 2.
  if $kind = 14
    set tg = 3.0
    set ti = 1.0
    set tr = 4.1
    set tf = 9.1
    set tag = "_bm3s"
    set sins = "_bmsempre"
    set srel = "_bmmai"
    set isev = 1
  end
  if $kind = 15
    set tg = 3.0
    set amp = 0
    set ti = 1.0
    set tr = 6.0
    set tf = 11.0
    set tag = "_lz3s"
    set sins = "_lzsempre"
    set srel = "_lzmai"
    set isev = 1
  end
  if $isev = 1
    set tipo = "evento"
    set mti = $ti
    set mtr = $tr
  else
    set mti = 1.0
    set mtr = 2.1
  end
  alter vamp dc = $amp
  alter vfrq dc = $frq
  * ---- la posizione ----
  if $g = 1
    set nm = "g1_jack"
    alter vmhjk dc = 0
    alter vtgjk dc = $tg
    alter vtijk dc = $ti
    alter vtrjk dc = $tr
  end
  if $g = 2
    set nm = "g2_prima"
    alter vmhpre dc = 0
    alter vtgpre dc = $tg
    alter vtipre dc = $ti
    alter vtrpre dc = $tr
  end
  if $g = 3
    set nm = "g3_prima_offset_zero"
    alter vmhpre dc = 0
    alter vtgpre dc = $tg
    alter vtipre dc = $ti
    alter vtrpre dc = $tr
    alter vosb dc = $scb
    alter vosf1 dc = $sc1
    alter vosf2 dc = $sc2
  end
  if $g = 4
    set nm = "g4_serie"
    alter vmhser dc = 0
    alter vtgser dc = $tg
    alter vtiser dc = $ti
    alter vtrser dc = $tr
    alter rbym = 1e12
    alter rby1 = 1e12
    alter rby2 = 1e12
    alter rbcm = 220k
    alter rbc1 = 470k
    alter rbc2 = 470k
  end
  set cell = "gr$g$rl$tag"
  tran 10u $tf 0 10u
  wrdata $cell$d v(mainjack) v(fixjack1) v(fixjack2)
  if $isev = 1
    echo "$cell,$cell$d,$nm,$frq,$amp,10,$rlv,$mti,$mtr,$tf,10e-6,$tipo,gr$g$rl$sins,gr$g$rl$srel,$tg" >> tb_v2_mute_graduale_manifest.csv
  else
    echo "$cell,$cell$d,$nm,$frq,$amp,10,$rlv,$mti,$mtr,$tf,10e-6,$tipo,-,-,0" >> tb_v2_mute_graduale_manifest.csv
  end
  destroy all
  end
end
end
end
.endc

.end
