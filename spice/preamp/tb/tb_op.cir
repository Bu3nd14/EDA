tb_op.cir - gain block operating point, BLOCK B wired as the output stage
* First line is a title (docs/limitations.md #10). Do not put a directive here.
* Models are PLACEHOLDERS: DC bias is credible, distortion is not.

* ---------------------------------------------------------------------
* CONVENZIONE DI PERCORSO (collaudata su questo deck in L2; L3 la replica
* sugli altri 11 senza riprogettarla). Due regole, una per meta'.
*
* LETTURA - `.include @REPO@/<percorso-dalla-radice-del-repo>`.
*   run_simulation.sh sostituisce @REPO@ con la radice del checkout di
*   cui lo script stesso fa parte, e scrive un deck derivato
*   <nome>_resolved.cir dentro la directory dei risultati.
*
*   Perche' non un percorso relativo: ngspice risolve un `.include`
*   relativo contro la DIRECTORY DI LAVORO, non contro la directory del
*   deck - e run_simulation.sh fa `cd "$OUTDIR"` prima di lanciare
*   ngspice. Verificato, non dedotto: due file entrambi chiamati
*   ../real.lib, uno raggiungibile dalla directory del deck (1 kohm) e
*   uno dal cwd (9 kohm); ngspice -b ha letto quello del cwd
*   (i(V1) = -1.111e-04 = 1/9k contro -1.000e-03 = 1/1k).
*
*   Un @REPO@ non sostituito fallisce in modo rumoroso: ngspice esce 1
*   con "Could not find include file". Non e' un fallimento silenzioso.
*
* SCRITTURA - `wrdata <nome-nudo>`, senza alcun percorso.
*   Lo stesso `cd "$OUTDIR"` lo fa atterrare nella directory dei
*   risultati da solo. Il nome <basename-del-deck>_wrdata.txt e' quello
*   che run_simulation.sh cerca per PRIMO (righe 80-90): usarlo evita il
*   fallback che fa `grep ... | head -1`.
*
*   Nota per L3/L5: un deck con PIU' di un `wrdata` (tb_dc_headroom.cir
*   ne ha 2) non puo' usare quel nome per entrambi e cade sul fallback,
*   che ne vede solo il primo. Va gestito, non ereditato per distrazione.
* ---------------------------------------------------------------------

.include @REPO@/spice/preamp/placeholder_devices.lib
* L22: the input current mirror is no longer a placeholder. It is an
* LS352 (ADR-018) and this is its VENDOR model - the only real device
* model in this deck besides the LSK489. Every OTHER device here is
* still a hand-written placeholder.
.include @REPO@/models/bjt_pnp/ls350.lib
.include @REPO@/spice/preamp/gain_block_flat.inc

VPP VPLUS 0 DC 15
VMM VMINUS 0 DC -15
VIN IN 0 DC 0 AC 1

* Gain relay: open contact = 0 dB. An open relay contact is not an infinite
* impedance, it is ~15 pF of stray with a very large leakage resistance.
CSTRAY RG 0 15p
RLEAK  RG 0 1G

* Output network of BLOCK B (main output), per E8 / ADR-007:
RISO  OUT OUTA 47
COUT  OUTA JACK 4.7u
RBLEED JACK 0 220k
RLOAD JACK 0 100k

.control
op
* Meta' scrittura della convenzione: nome nudo, nessun percorso.
wrdata tb_op_wrdata.txt v(OUT) v(JACK) v(FB) v(SRC) i(VPP) i(VMM)
echo "=== NODE VOLTAGES ==="
print v(IN) v(FB) v(OUT) v(JACK) v(NREF) v(NREFM) v(NCASC) v(SRC)
print v(G1) v(G2) v(S1) v(S2) v(D1N) v(D2N) v(NMIRI) v(NHI)
print v(NX) v(NY) v(NBB) v(NBN) v(NBP) v(NEN) v(NEP) v(NVE) v(NVLE) v(NTE)
echo "=== INPUT JFET PAIR (LSK489 halves) ==="
print @jq110[id]
print @jq111[id]
print @jq110[vgs]
print @jq111[vgs]
print @jq110[gm]
print @jq111[gm]
echo "=== RAIL CURRENTS (A) ==="
print i(VPP) i(VMM)
echo "=== BJT OPERATING POINTS: ic / vce ==="
print @q106[ic] @q106[ib] @q106[vbe] @q106[vbc]
print @q118[ic] @q118[ib] @q118[vbe] @q118[vbc]
print @q119[ic] @q119[ib] @q119[vbe] @q119[vbc]
print @q122A[ic] @q122A[ib] @q122A[vbe] @q122A[vbc]
print @q122B[ic] @q122B[ib] @q122B[vbe] @q122B[vbc]
print @q123[ic] @q123[ib] @q123[vbe] @q123[vbc]
print @q126[ic] @q126[ib] @q126[vbe] @q126[vbc]
print @q128[ic] @q128[ib] @q128[vbe] @q128[vbc]
print @q133[ic] @q133[ib] @q133[vbe] @q133[vbc]
print @q134[ic] @q134[ib] @q134[vbe] @q134[vbc]
echo "=== KEY BRANCH CURRENTS ==="
print @riso[i] @r137[i] @r135[i] @r136[i] @r107[i] @r124[i] @r127[i]
.endc

.end
