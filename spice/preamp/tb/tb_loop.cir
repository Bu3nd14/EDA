tb_loop.cir - loop gain and phase margin, V1 matrix (gain mode x capacitive load)
* METHOD: voltage injection at the inverting JFET gate. That node draws no
* current (JFET gate, ~1e12 ohm) while the feedback network drives it from
* ~470 ohm, so simple voltage injection is exact here - no Middlebrook
* correction needed. The deck OPENS the generated gate stopper R109 and
* re-creates it as RBRK + a DC=0 AC=1 source, so the loop topology and the DC
* bias are untouched; only the injection point is added.
*
* T = V(FB)/V(G2). G2 is the INVERTING input, so T is negative real at DC:
* its phase there is 180 deg. Phase margin is therefore read directly as
* |ph(T)| at the frequency where |T| = 1.
*
* *** THE NUMBERS FROM THIS DECK ARE PROVISIONAL ***
* Phase margin is set by device capacitances and transit times. Every one of
* those in placeholder_devices.lib was CHOSEN BY HAND at a plausible order of
* magnitude, not fitted to a datasheet. This deck exists so the design is not
* flying blind; measurement-analyst must re-run it against vendor models.

.include @REPO@/spice/preamp/placeholder_devices.lib
.include @REPO@/spice/preamp/gain_block_flat.inc

VPP VPLUS 0 DC 15
VMM VMINUS 0 DC -15
VIN IN 0 DC 0

CSTRAY RG 0 15p
RRG    RG 0 1G

* loop break, substituting for the generated 100 ohm gate stopper R109
RBRK FB NBRK 100
VINJ NBRK G2 DC 0 AC 1

* BLOCK B output network + cable. CCABLE is altered in the loop below.
RISO   OUT OUTA 47
COUT   OUTA JACK 4.7u
RBLEED JACK 0 220k
RLOAD  JACK 0 100k
CCABLE JACK 0 1f

.control
* --- wrdata (L5): una curva di anello PER ITERAZIONE, 12 file ---------
* NOMI PARAMETRIZZATI: un `$var` in un nome di file non si chiude da solo
* - ngspice fa entrare nel nome della variabile anche `.`, `-` e `_`,
* quindi `wrdata tb_loop_$cab.txt` cercherebbe la variabile "cab.txt". Un
* `$` invece TERMINA il nome: la forma che funziona e' `$cab$t` con
* t = ".txt" e u = "_". Misurato con una sonda in L5, non dedotto.
*
* ETICHETTE: 0db/10db nel nome invece del valore di RRG. Il `foreach`
* resta pero' quello di prima e l'etichetta si ricava con un `if`, cosi'
* `alter` e l'echo usano ancora i valori originali e il log resta
* confrontabile riga per riga con quello di prima della modifica.
*
* DOVE: dentro il ciclo interno, PRIMA del `destroy all`. Senza quel
* destroy ogni `ac` creerebbe ac2, ac3, ... e un `wrdata` fuori dal ciclo
* leggerebbe il plot sbagliato in silenzio (docs/limitations.md #10).
*
* I 12 FILE: tb_loop_{0db,10db}_{1f,100p,470p,1n,2.2n,4.7n}.txt
* Nessuno si chiama tb_loop_wrdata.txt - il deck non ha una sezione fuori
* ciclo - quindi run_simulation.sh avvisa e scrive un tb_loop.json con
* rows: 0, e i 12 file veri li converte il SECONDO passaggio. E' atteso.
*
* COLONNE (~801 righe, 1 Hz - 100 MHz, 100 punti/decade). Per ogni vettore
* una COPPIA (frequenza, valore): le PARI sono la frequenza ripetuta, i
* dati sono le DISPARI.
*   col0 = frequenza [Hz]   col1 = Tdb = |T| in dB
*   col2 = frequenza [Hz]   col3 = Tph = fase di T in GRADI
* T = v(FB)/v(G2), e G2 e' l'ingresso INVERTENTE: T e' negativo reale in
* continua, quindi la sua fase li' vale 180 gradi e il margine di fase si
* legge come |Tph| dove Tdb attraversa lo zero. Non e' 180 - |Tph|.
*
* PROVVISORIO: le capacita' dei modelli segnaposto sono scelte a mano, non
* fittate su datasheet. Il margine di fase che esce di qui va rifatto sui
* modelli vendor (L6-L7) prima di poter essere citato.
* ---------------------------------------------------------------------
set t = .txt
set u = "_"
alter r109 = 1G
set units = degrees
foreach mode 1G 0.1
  alter rrg = $mode
  if $mode = 1G
    set gm = "0db"
  end
  if $mode = 0.1
    set gm = "10db"
  end
  foreach cab 1f 100p 470p 1n 2.2n 4.7n
    alter ccable = $cab
    ac dec 100 1 100meg
    let T = v(fb)/v(g2)
    let Tdb = db(T)
    let Tph = ph(T)
    meas ac fcross when Tdb=0
    meas ac pmarg find Tph when Tdb=0
    meas ac tdc find Tdb at=10
    echo "mode(RRG)=$mode  Ccable=$cab"
    print fcross pmarg tdc
    wrdata tb_loop_$gm$u$cab$t Tdb Tph
    destroy all
  end
end
.endc

.end
