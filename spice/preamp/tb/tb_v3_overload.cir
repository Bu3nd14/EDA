tb_v3_overload.cir - V3 overload recovery, and a Fourier run that proves nothing
* PART 1 (V3): +10 dB mode, 1 kHz, driven at 8 V pk - 5.6 dB past the 4.18 V pk
* input that clips the stage - for 5 cycles, then back to a 0.5 V pk burst.
* Measures how long the output takes to return to its linear envelope.
* A discrete feedback amplifier can latch or take milliseconds to recover;
* the requirement says verify, not assume.
*
* PART 2: a .four run at 1 kHz. IT IS INCLUDED FOR COMPLETENESS AND ITS
* RESULT IS MEANINGLESS AS A DISTORTION FIGURE. placeholder_devices.lib was
* authored by hand: its BF/VAF/IS/TF were picked at plausible orders of
* magnitude and fitted to NOTHING. Distortion is precisely the property that
* lives in the parts of a model nobody guessed correctly. Do not quote the
* number. It is here only to show the stage produces a clean-looking sine
* rather than something pathological, and to give measurement-analyst a
* deck that is ready to re-run the moment vendor models exist.

.include @REPO@/spice/preamp/placeholder_devices.lib
* L22: the input current mirror is no longer a placeholder. It is an
* LS352 (ADR-018) and this is its VENDOR model - the only real device
* model in this deck besides the LSK489. Every OTHER device here is
* still a hand-written placeholder.
.include @REPO@/models/bjt_pnp/ls350.lib
.include @REPO@/spice/preamp/gain_block_flat.inc

VPP VPLUS 0 DC 15
VMM VMINUS 0 DC -15
* 3.5 V pk from 1 ms to 6 ms, then 0.5 V pk - built from two sines gated by
* PWL amplitude is not available, so use a PWL-driven behavioural source.
VBIG  NBIG 0 SIN(0 1 1k)
VGATE NGATE 0 PWL(0 0.5 0.999m 0.5 1.000m 8.0 6.000m 8.0 6.001m 0.5 20m 0.5)
BSRC  SRCN 0 V = V(NBIG)*V(NGATE)
RSRC  SRCN IN 430

CSTRAY RG 0 15p
CSTRAY10 RG10 0 15p
RRG    RG 0 0.1
RRG10  RG10 0 0.1

RISO   OUT OUTA 47
COUT   OUTA JACK 4.7u
RBLEED JACK 0 220k
RLOAD  JACK 0 100k

.control
tran 1u 20m 0 1u
wrdata tb_v3_overload_wrdata.txt v(SRCN) v(OUT) v(JACK) v(NX)
echo "PART 2 - Fourier at 1 kHz. THE THD NUMBER BELOW IS MEANINGLESS."
alter @vgate[pwl] = [ 0 0.5 20m 0.5 ]
tran 1u 20m 10m 1u
fourier 1000 v(OUT)
.endc

.end
